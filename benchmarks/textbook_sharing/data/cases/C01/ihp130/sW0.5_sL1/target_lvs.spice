.subckt C01_ihp130_sW0.5_sL1 VSS IB1 IOUT1
XM1_f0 IB1 IB1 VSS VSS sg13_lv_nmos w=0.5u l=1.04u
XM1_f1 IB1 IB1 VSS VSS sg13_lv_nmos w=0.5u l=1.04u
XM2_f0 IOUT1 IB1 VSS VSS sg13_lv_nmos w=0.5u l=1.04u
XM2_f1 IOUT1 IB1 VSS VSS sg13_lv_nmos w=0.5u l=1.04u
.ends C01_ihp130_sW0.5_sL1
