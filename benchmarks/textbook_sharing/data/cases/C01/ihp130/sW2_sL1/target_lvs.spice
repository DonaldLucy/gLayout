.subckt C01_ihp130_sW2_sL1 VSS IB1 IOUT1
XM1_f0 IB1 IB1 VSS VSS sg13_lv_nmos w=0.5u l=1.04u
XM1_f1 IB1 IB1 VSS VSS sg13_lv_nmos w=0.5u l=1.04u
XM1_f2 IB1 IB1 VSS VSS sg13_lv_nmos w=0.5u l=1.04u
XM1_f3 IB1 IB1 VSS VSS sg13_lv_nmos w=0.5u l=1.04u
XM1_f4 IB1 IB1 VSS VSS sg13_lv_nmos w=0.5u l=1.04u
XM1_f5 IB1 IB1 VSS VSS sg13_lv_nmos w=0.5u l=1.04u
XM1_f6 IB1 IB1 VSS VSS sg13_lv_nmos w=0.5u l=1.04u
XM1_f7 IB1 IB1 VSS VSS sg13_lv_nmos w=0.5u l=1.04u
XM2_f0 IOUT1 IB1 VSS VSS sg13_lv_nmos w=0.5u l=1.04u
XM2_f1 IOUT1 IB1 VSS VSS sg13_lv_nmos w=0.5u l=1.04u
XM2_f2 IOUT1 IB1 VSS VSS sg13_lv_nmos w=0.5u l=1.04u
XM2_f3 IOUT1 IB1 VSS VSS sg13_lv_nmos w=0.5u l=1.04u
XM2_f4 IOUT1 IB1 VSS VSS sg13_lv_nmos w=0.5u l=1.04u
XM2_f5 IOUT1 IB1 VSS VSS sg13_lv_nmos w=0.5u l=1.04u
XM2_f6 IOUT1 IB1 VSS VSS sg13_lv_nmos w=0.5u l=1.04u
XM2_f7 IOUT1 IB1 VSS VSS sg13_lv_nmos w=0.5u l=1.04u
.ends C01_ihp130_sW2_sL1
