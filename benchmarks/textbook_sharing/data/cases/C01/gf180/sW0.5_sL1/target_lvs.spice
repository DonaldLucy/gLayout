.subckt C01_gf180_sW0.5_sL1 VSS IB1 IOUT1
MM1_f0 IB1 IB1 VSS VSS nfet_03v3 w=0.5u l=1.12u
MM1_f1 IB1 IB1 VSS VSS nfet_03v3 w=0.5u l=1.12u
MM2_f0 IOUT1 IB1 VSS VSS nfet_03v3 w=0.5u l=1.12u
MM2_f1 IOUT1 IB1 VSS VSS nfet_03v3 w=0.5u l=1.12u
.ends C01_gf180_sW0.5_sL1
