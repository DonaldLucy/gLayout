.subckt C01_sky130_sW1.5_sL1.5 VSS IB1 IOUT1
XM1 IB1 IB1 VSS VSS sky130_fd_pr__nfet_01v8 w=3 l=0.9 nf=6
XM2 IOUT1 IB1 VSS VSS sky130_fd_pr__nfet_01v8 w=3 l=0.9 nf=6
.ends C01_sky130_sW1.5_sL1.5
