.subckt C01_sky130_sW0.5_sL1.5 VSS IB1 IOUT1
XM1_f0 IB1 IB1 VSS VSS sky130_fd_pr__nfet_01v8 w=0.5 l=0.9
XM1_f1 IB1 IB1 VSS VSS sky130_fd_pr__nfet_01v8 w=0.5 l=0.9
XM2_f0 IOUT1 IB1 VSS VSS sky130_fd_pr__nfet_01v8 w=0.5 l=0.9
XM2_f1 IOUT1 IB1 VSS VSS sky130_fd_pr__nfet_01v8 w=0.5 l=0.9
.ends C01_sky130_sW0.5_sL1.5
