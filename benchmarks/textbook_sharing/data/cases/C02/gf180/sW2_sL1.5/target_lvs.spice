.subckt C02_gf180_sW2_sL1.5 VSS IIN1 IOUT1
MM1_f0 IIN1 IIN1 net6 VSS nfet_03v3 w=0.5u l=0.84u
MM1_f1 IIN1 IIN1 net6 VSS nfet_03v3 w=0.5u l=0.84u
MM1_f2 IIN1 IIN1 net6 VSS nfet_03v3 w=0.5u l=0.84u
MM1_f3 IIN1 IIN1 net6 VSS nfet_03v3 w=0.5u l=0.84u
MM1_f4 IIN1 IIN1 net6 VSS nfet_03v3 w=0.5u l=0.84u
MM1_f5 IIN1 IIN1 net6 VSS nfet_03v3 w=0.5u l=0.84u
MM1_f6 IIN1 IIN1 net6 VSS nfet_03v3 w=0.5u l=0.84u
MM1_f7 IIN1 IIN1 net6 VSS nfet_03v3 w=0.5u l=0.84u
MM2_f0 net6 net6 VSS VSS nfet_03v3 w=0.5u l=0.84u
MM2_f1 net6 net6 VSS VSS nfet_03v3 w=0.5u l=0.84u
MM2_f2 net6 net6 VSS VSS nfet_03v3 w=0.5u l=0.84u
MM2_f3 net6 net6 VSS VSS nfet_03v3 w=0.5u l=0.84u
MM2_f4 net6 net6 VSS VSS nfet_03v3 w=0.5u l=0.84u
MM2_f5 net6 net6 VSS VSS nfet_03v3 w=0.5u l=0.84u
MM2_f6 net6 net6 VSS VSS nfet_03v3 w=0.5u l=0.84u
MM2_f7 net6 net6 VSS VSS nfet_03v3 w=0.5u l=0.84u
MM3_f0 IOUT1 IIN1 net12 VSS nfet_03v3 w=0.5u l=0.84u
MM3_f1 IOUT1 IIN1 net12 VSS nfet_03v3 w=0.5u l=0.84u
MM3_f2 IOUT1 IIN1 net12 VSS nfet_03v3 w=0.5u l=0.84u
MM3_f3 IOUT1 IIN1 net12 VSS nfet_03v3 w=0.5u l=0.84u
MM3_f4 IOUT1 IIN1 net12 VSS nfet_03v3 w=0.5u l=0.84u
MM3_f5 IOUT1 IIN1 net12 VSS nfet_03v3 w=0.5u l=0.84u
MM3_f6 IOUT1 IIN1 net12 VSS nfet_03v3 w=0.5u l=0.84u
MM3_f7 IOUT1 IIN1 net12 VSS nfet_03v3 w=0.5u l=0.84u
MM4_f0 net12 net6 VSS VSS nfet_03v3 w=0.5u l=0.84u
MM4_f1 net12 net6 VSS VSS nfet_03v3 w=0.5u l=0.84u
MM4_f2 net12 net6 VSS VSS nfet_03v3 w=0.5u l=0.84u
MM4_f3 net12 net6 VSS VSS nfet_03v3 w=0.5u l=0.84u
MM4_f4 net12 net6 VSS VSS nfet_03v3 w=0.5u l=0.84u
MM4_f5 net12 net6 VSS VSS nfet_03v3 w=0.5u l=0.84u
MM4_f6 net12 net6 VSS VSS nfet_03v3 w=0.5u l=0.84u
MM4_f7 net12 net6 VSS VSS nfet_03v3 w=0.5u l=0.84u
.ends C02_gf180_sW2_sL1.5
