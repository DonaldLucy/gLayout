.subckt C02_gf180_sW1_sL1 VSS IIN1 IOUT1
MM1_f0 IIN1 IIN1 net6 VSS nfet_03v3 w=0.5u l=0.56u
MM1_f1 IIN1 IIN1 net6 VSS nfet_03v3 w=0.5u l=0.56u
MM1_f2 IIN1 IIN1 net6 VSS nfet_03v3 w=0.5u l=0.56u
MM1_f3 IIN1 IIN1 net6 VSS nfet_03v3 w=0.5u l=0.56u
MM2_f0 net6 net6 VSS VSS nfet_03v3 w=0.5u l=0.56u
MM2_f1 net6 net6 VSS VSS nfet_03v3 w=0.5u l=0.56u
MM2_f2 net6 net6 VSS VSS nfet_03v3 w=0.5u l=0.56u
MM2_f3 net6 net6 VSS VSS nfet_03v3 w=0.5u l=0.56u
MM3_f0 IOUT1 IIN1 net12 VSS nfet_03v3 w=0.5u l=0.56u
MM3_f1 IOUT1 IIN1 net12 VSS nfet_03v3 w=0.5u l=0.56u
MM3_f2 IOUT1 IIN1 net12 VSS nfet_03v3 w=0.5u l=0.56u
MM3_f3 IOUT1 IIN1 net12 VSS nfet_03v3 w=0.5u l=0.56u
MM4_f0 net12 net6 VSS VSS nfet_03v3 w=0.5u l=0.56u
MM4_f1 net12 net6 VSS VSS nfet_03v3 w=0.5u l=0.56u
MM4_f2 net12 net6 VSS VSS nfet_03v3 w=0.5u l=0.56u
MM4_f3 net12 net6 VSS VSS nfet_03v3 w=0.5u l=0.56u
.ends C02_gf180_sW1_sL1
