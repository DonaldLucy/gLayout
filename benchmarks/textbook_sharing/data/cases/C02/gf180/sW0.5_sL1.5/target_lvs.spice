.subckt C02_gf180_sW0.5_sL1.5 VSS IIN1 IOUT1
MM1_f0 IIN1 IIN1 net6 VSS nfet_03v3 w=0.5u l=0.84u
MM1_f1 IIN1 IIN1 net6 VSS nfet_03v3 w=0.5u l=0.84u
MM2_f0 net6 net6 VSS VSS nfet_03v3 w=0.5u l=0.84u
MM2_f1 net6 net6 VSS VSS nfet_03v3 w=0.5u l=0.84u
MM3_f0 IOUT1 IIN1 net12 VSS nfet_03v3 w=0.5u l=0.84u
MM3_f1 IOUT1 IIN1 net12 VSS nfet_03v3 w=0.5u l=0.84u
MM4_f0 net12 net6 VSS VSS nfet_03v3 w=0.5u l=0.84u
MM4_f1 net12 net6 VSS VSS nfet_03v3 w=0.5u l=0.84u
.ends C02_gf180_sW0.5_sL1.5
