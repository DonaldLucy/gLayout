.subckt C02_ihp130_sW1_sL2 VSS IIN1 IOUT1
XM1_f0 IIN1 IIN1 net6 VSS sg13_lv_nmos w=0.5u l=1.04u
XM1_f1 IIN1 IIN1 net6 VSS sg13_lv_nmos w=0.5u l=1.04u
XM1_f2 IIN1 IIN1 net6 VSS sg13_lv_nmos w=0.5u l=1.04u
XM1_f3 IIN1 IIN1 net6 VSS sg13_lv_nmos w=0.5u l=1.04u
XM2_f0 net6 net6 VSS VSS sg13_lv_nmos w=0.5u l=1.04u
XM2_f1 net6 net6 VSS VSS sg13_lv_nmos w=0.5u l=1.04u
XM2_f2 net6 net6 VSS VSS sg13_lv_nmos w=0.5u l=1.04u
XM2_f3 net6 net6 VSS VSS sg13_lv_nmos w=0.5u l=1.04u
XM3_f0 IOUT1 IIN1 net12 VSS sg13_lv_nmos w=0.5u l=1.04u
XM3_f1 IOUT1 IIN1 net12 VSS sg13_lv_nmos w=0.5u l=1.04u
XM3_f2 IOUT1 IIN1 net12 VSS sg13_lv_nmos w=0.5u l=1.04u
XM3_f3 IOUT1 IIN1 net12 VSS sg13_lv_nmos w=0.5u l=1.04u
XM4_f0 net12 net6 VSS VSS sg13_lv_nmos w=0.5u l=1.04u
XM4_f1 net12 net6 VSS VSS sg13_lv_nmos w=0.5u l=1.04u
XM4_f2 net12 net6 VSS VSS sg13_lv_nmos w=0.5u l=1.04u
XM4_f3 net12 net6 VSS VSS sg13_lv_nmos w=0.5u l=1.04u
.ends C02_ihp130_sW1_sL2
