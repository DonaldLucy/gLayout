.subckt C02_ihp130_sW2_sL1 VSS IIN1 IOUT1
XM1_f0 IIN1 IIN1 net6 VSS sg13_lv_nmos w=0.5u l=0.52u
XM1_f1 IIN1 IIN1 net6 VSS sg13_lv_nmos w=0.5u l=0.52u
XM1_f2 IIN1 IIN1 net6 VSS sg13_lv_nmos w=0.5u l=0.52u
XM1_f3 IIN1 IIN1 net6 VSS sg13_lv_nmos w=0.5u l=0.52u
XM1_f4 IIN1 IIN1 net6 VSS sg13_lv_nmos w=0.5u l=0.52u
XM1_f5 IIN1 IIN1 net6 VSS sg13_lv_nmos w=0.5u l=0.52u
XM1_f6 IIN1 IIN1 net6 VSS sg13_lv_nmos w=0.5u l=0.52u
XM1_f7 IIN1 IIN1 net6 VSS sg13_lv_nmos w=0.5u l=0.52u
XM2_f0 net6 net6 VSS VSS sg13_lv_nmos w=0.5u l=0.52u
XM2_f1 net6 net6 VSS VSS sg13_lv_nmos w=0.5u l=0.52u
XM2_f2 net6 net6 VSS VSS sg13_lv_nmos w=0.5u l=0.52u
XM2_f3 net6 net6 VSS VSS sg13_lv_nmos w=0.5u l=0.52u
XM2_f4 net6 net6 VSS VSS sg13_lv_nmos w=0.5u l=0.52u
XM2_f5 net6 net6 VSS VSS sg13_lv_nmos w=0.5u l=0.52u
XM2_f6 net6 net6 VSS VSS sg13_lv_nmos w=0.5u l=0.52u
XM2_f7 net6 net6 VSS VSS sg13_lv_nmos w=0.5u l=0.52u
XM3_f0 IOUT1 IIN1 net12 VSS sg13_lv_nmos w=0.5u l=0.52u
XM3_f1 IOUT1 IIN1 net12 VSS sg13_lv_nmos w=0.5u l=0.52u
XM3_f2 IOUT1 IIN1 net12 VSS sg13_lv_nmos w=0.5u l=0.52u
XM3_f3 IOUT1 IIN1 net12 VSS sg13_lv_nmos w=0.5u l=0.52u
XM3_f4 IOUT1 IIN1 net12 VSS sg13_lv_nmos w=0.5u l=0.52u
XM3_f5 IOUT1 IIN1 net12 VSS sg13_lv_nmos w=0.5u l=0.52u
XM3_f6 IOUT1 IIN1 net12 VSS sg13_lv_nmos w=0.5u l=0.52u
XM3_f7 IOUT1 IIN1 net12 VSS sg13_lv_nmos w=0.5u l=0.52u
XM4_f0 net12 net6 VSS VSS sg13_lv_nmos w=0.5u l=0.52u
XM4_f1 net12 net6 VSS VSS sg13_lv_nmos w=0.5u l=0.52u
XM4_f2 net12 net6 VSS VSS sg13_lv_nmos w=0.5u l=0.52u
XM4_f3 net12 net6 VSS VSS sg13_lv_nmos w=0.5u l=0.52u
XM4_f4 net12 net6 VSS VSS sg13_lv_nmos w=0.5u l=0.52u
XM4_f5 net12 net6 VSS VSS sg13_lv_nmos w=0.5u l=0.52u
XM4_f6 net12 net6 VSS VSS sg13_lv_nmos w=0.5u l=0.52u
XM4_f7 net12 net6 VSS VSS sg13_lv_nmos w=0.5u l=0.52u
.ends C02_ihp130_sW2_sL1
