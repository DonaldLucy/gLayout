.subckt C14_gf180_sW0.5_sL2 VSS IIN1 IOUT1 IREF1
MM1 IIN1 IIN1 VSS VSS nfet_03v3 w=1u l=2.24u nf=2 m=1
MM2 net11 IIN1 VSS VSS nfet_03v3 w=1u l=2.24u nf=2 m=1
MM3 IREF1 net11 VSS VSS nfet_03v3 w=0.5u l=2.24u nf=1 m=1
MM4 IOUT1 IREF1 net11 VSS nfet_03v3 w=1u l=2.24u nf=2 m=1
.ends C14_gf180_sW0.5_sL2
