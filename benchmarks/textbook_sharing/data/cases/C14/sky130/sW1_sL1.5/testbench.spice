X1 VSS IIN1 IOUT1 IREF1 C14_sky130_sW1_sL1.5
.include DUT_INCLUDE_PATH
VSS VSS 0 0
VDDB VDDB 0 1.8
IIIN1 VDDB IIN1 2e-05
IIREF1 VDDB IREF1 5e-06
.nodeset v(IIN1)=0.54 v(IREF1)=0.54

VOUT IOUT1 0 1.8
.control
dc VOUT 1.8 0 -0.0045
let iout = -i(VOUT)
let dev = abs(iout - 2e-05)/2e-05
meas dc iout_t find iout at=1.21
let err = (iout_t - 2e-05)/2e-05
print err
meas dc vmin find v(IOUT1) when dev=0.03 cross=last
meas dc dev_at_vdd find dev at=1.791
let gout = deriv(iout)
meas dc gout_t find gout at=1.21
let rout_v = 1/gout
meas dc rout_t find rout_v at=1.21
echo vout_test = 1.21
quit
.endc
.end
