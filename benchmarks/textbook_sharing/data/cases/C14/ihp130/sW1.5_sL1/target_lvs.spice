.subckt C14_ihp130_sW1.5_sL1 VSS IIN1 IOUT1 IREF1
XM1_f0 IIN1 IIN1 VSS VSS sg13_lv_nmos w=0.5u l=1.04u
XM1_f1 IIN1 IIN1 VSS VSS sg13_lv_nmos w=0.5u l=1.04u
XM1_f2 IIN1 IIN1 VSS VSS sg13_lv_nmos w=0.5u l=1.04u
XM1_f3 IIN1 IIN1 VSS VSS sg13_lv_nmos w=0.5u l=1.04u
XM1_f4 IIN1 IIN1 VSS VSS sg13_lv_nmos w=0.5u l=1.04u
XM1_f5 IIN1 IIN1 VSS VSS sg13_lv_nmos w=0.5u l=1.04u
XM2_f0 net11 IIN1 VSS VSS sg13_lv_nmos w=0.5u l=1.04u
XM2_f1 net11 IIN1 VSS VSS sg13_lv_nmos w=0.5u l=1.04u
XM2_f2 net11 IIN1 VSS VSS sg13_lv_nmos w=0.5u l=1.04u
XM2_f3 net11 IIN1 VSS VSS sg13_lv_nmos w=0.5u l=1.04u
XM2_f4 net11 IIN1 VSS VSS sg13_lv_nmos w=0.5u l=1.04u
XM2_f5 net11 IIN1 VSS VSS sg13_lv_nmos w=0.5u l=1.04u
XM3_f0 IREF1 net11 VSS VSS sg13_lv_nmos w=0.5u l=1.04u
XM3_f1 IREF1 net11 VSS VSS sg13_lv_nmos w=0.5u l=1.04u
XM3_f2 IREF1 net11 VSS VSS sg13_lv_nmos w=0.5u l=1.04u
XM4_f0 IOUT1 IREF1 net11 VSS sg13_lv_nmos w=0.5u l=1.04u
XM4_f1 IOUT1 IREF1 net11 VSS sg13_lv_nmos w=0.5u l=1.04u
XM4_f2 IOUT1 IREF1 net11 VSS sg13_lv_nmos w=0.5u l=1.04u
XM4_f3 IOUT1 IREF1 net11 VSS sg13_lv_nmos w=0.5u l=1.04u
XM4_f4 IOUT1 IREF1 net11 VSS sg13_lv_nmos w=0.5u l=1.04u
XM4_f5 IOUT1 IREF1 net11 VSS sg13_lv_nmos w=0.5u l=1.04u
.ends C14_ihp130_sW1.5_sL1
