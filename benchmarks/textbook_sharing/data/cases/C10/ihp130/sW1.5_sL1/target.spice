.subckt C10_ihp130_sW1.5_sL1 VDD VSS VIN1 VIN2 VOUT1 VOUT2 VB1 VB2 VB3 VB4 IB1
XM1 net022 VIN1 IB1 VDD sg13_lv_pmos w=6u l=0.52u ng=12 m=1
XM2 net018 VIN2 IB1 VDD sg13_lv_pmos w=6u l=0.52u ng=12 m=1
XM3 net022 VB4 VSS VSS sg13_lv_nmos w=6u l=0.52u ng=12 m=1
XM4 net018 VB4 VSS VSS sg13_lv_nmos w=6u l=0.52u ng=12 m=1
XM5 VOUT1 VB1 net022 VSS sg13_lv_nmos w=6u l=0.52u ng=12 m=1
XM6 VOUT2 VB1 net018 VSS sg13_lv_nmos w=6u l=0.52u ng=12 m=1
XM7 VOUT1 VB2 net023 VDD sg13_lv_pmos w=6u l=0.52u ng=12 m=1
XM8 VOUT2 VB2 net021 VDD sg13_lv_pmos w=6u l=0.52u ng=12 m=1
XM9 net023 VB3 VDD VDD sg13_lv_pmos w=6u l=0.52u ng=12 m=1
XM10 net021 VB3 VDD VDD sg13_lv_pmos w=6u l=0.52u ng=12 m=1
.ends C10_ihp130_sW1.5_sL1
