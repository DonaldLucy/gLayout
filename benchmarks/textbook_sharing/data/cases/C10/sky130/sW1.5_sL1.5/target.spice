.subckt C10_sky130_sW1.5_sL1.5 VDD VSS VIN1 VIN2 VOUT1 VOUT2 VB1 VB2 VB3 VB4 IB1
XM1 net022 VIN1 IB1 VDD sky130_fd_pr__pfet_01v8 w=6 l=0.9 nf=12
XM2 net018 VIN2 IB1 VDD sky130_fd_pr__pfet_01v8 w=6 l=0.9 nf=12
XM3 net022 VB4 VSS VSS sky130_fd_pr__nfet_01v8 w=6 l=0.9 nf=12
XM4 net018 VB4 VSS VSS sky130_fd_pr__nfet_01v8 w=6 l=0.9 nf=12
XM5 VOUT1 VB1 net022 VSS sky130_fd_pr__nfet_01v8 w=6 l=0.9 nf=12
XM6 VOUT2 VB1 net018 VSS sky130_fd_pr__nfet_01v8 w=6 l=0.9 nf=12
XM7 VOUT1 VB2 net023 VDD sky130_fd_pr__pfet_01v8 w=6 l=0.9 nf=12
XM8 VOUT2 VB2 net021 VDD sky130_fd_pr__pfet_01v8 w=6 l=0.9 nf=12
XM9 net023 VB3 VDD VDD sky130_fd_pr__pfet_01v8 w=6 l=0.9 nf=12
XM10 net021 VB3 VDD VDD sky130_fd_pr__pfet_01v8 w=6 l=0.9 nf=12
.ends C10_sky130_sW1.5_sL1.5
