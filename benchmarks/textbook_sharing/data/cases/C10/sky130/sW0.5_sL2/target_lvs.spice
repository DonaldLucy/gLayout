.subckt C10_sky130_sW0.5_sL2 VDD VSS VIN1 VIN2 VOUT1 VOUT2 VB1 VB2 VB3 VB4 IB1
XM1_f0 net022 VIN1 IB1 VDD sky130_fd_pr__pfet_01v8 w=0.5 l=1.2
XM1_f1 net022 VIN1 IB1 VDD sky130_fd_pr__pfet_01v8 w=0.5 l=1.2
XM1_f2 net022 VIN1 IB1 VDD sky130_fd_pr__pfet_01v8 w=0.5 l=1.2
XM1_f3 net022 VIN1 IB1 VDD sky130_fd_pr__pfet_01v8 w=0.5 l=1.2
XM2_f0 net018 VIN2 IB1 VDD sky130_fd_pr__pfet_01v8 w=0.5 l=1.2
XM2_f1 net018 VIN2 IB1 VDD sky130_fd_pr__pfet_01v8 w=0.5 l=1.2
XM2_f2 net018 VIN2 IB1 VDD sky130_fd_pr__pfet_01v8 w=0.5 l=1.2
XM2_f3 net018 VIN2 IB1 VDD sky130_fd_pr__pfet_01v8 w=0.5 l=1.2
XM3_f0 net022 VB4 VSS VSS sky130_fd_pr__nfet_01v8 w=0.5 l=1.2
XM3_f1 net022 VB4 VSS VSS sky130_fd_pr__nfet_01v8 w=0.5 l=1.2
XM3_f2 net022 VB4 VSS VSS sky130_fd_pr__nfet_01v8 w=0.5 l=1.2
XM3_f3 net022 VB4 VSS VSS sky130_fd_pr__nfet_01v8 w=0.5 l=1.2
XM4_f0 net018 VB4 VSS VSS sky130_fd_pr__nfet_01v8 w=0.5 l=1.2
XM4_f1 net018 VB4 VSS VSS sky130_fd_pr__nfet_01v8 w=0.5 l=1.2
XM4_f2 net018 VB4 VSS VSS sky130_fd_pr__nfet_01v8 w=0.5 l=1.2
XM4_f3 net018 VB4 VSS VSS sky130_fd_pr__nfet_01v8 w=0.5 l=1.2
XM5_f0 VOUT1 VB1 net022 VSS sky130_fd_pr__nfet_01v8 w=0.5 l=1.2
XM5_f1 VOUT1 VB1 net022 VSS sky130_fd_pr__nfet_01v8 w=0.5 l=1.2
XM5_f2 VOUT1 VB1 net022 VSS sky130_fd_pr__nfet_01v8 w=0.5 l=1.2
XM5_f3 VOUT1 VB1 net022 VSS sky130_fd_pr__nfet_01v8 w=0.5 l=1.2
XM6_f0 VOUT2 VB1 net018 VSS sky130_fd_pr__nfet_01v8 w=0.5 l=1.2
XM6_f1 VOUT2 VB1 net018 VSS sky130_fd_pr__nfet_01v8 w=0.5 l=1.2
XM6_f2 VOUT2 VB1 net018 VSS sky130_fd_pr__nfet_01v8 w=0.5 l=1.2
XM6_f3 VOUT2 VB1 net018 VSS sky130_fd_pr__nfet_01v8 w=0.5 l=1.2
XM7_f0 VOUT1 VB2 net023 VDD sky130_fd_pr__pfet_01v8 w=0.5 l=1.2
XM7_f1 VOUT1 VB2 net023 VDD sky130_fd_pr__pfet_01v8 w=0.5 l=1.2
XM7_f2 VOUT1 VB2 net023 VDD sky130_fd_pr__pfet_01v8 w=0.5 l=1.2
XM7_f3 VOUT1 VB2 net023 VDD sky130_fd_pr__pfet_01v8 w=0.5 l=1.2
XM8_f0 VOUT2 VB2 net021 VDD sky130_fd_pr__pfet_01v8 w=0.5 l=1.2
XM8_f1 VOUT2 VB2 net021 VDD sky130_fd_pr__pfet_01v8 w=0.5 l=1.2
XM8_f2 VOUT2 VB2 net021 VDD sky130_fd_pr__pfet_01v8 w=0.5 l=1.2
XM8_f3 VOUT2 VB2 net021 VDD sky130_fd_pr__pfet_01v8 w=0.5 l=1.2
XM9_f0 net023 VB3 VDD VDD sky130_fd_pr__pfet_01v8 w=0.5 l=1.2
XM9_f1 net023 VB3 VDD VDD sky130_fd_pr__pfet_01v8 w=0.5 l=1.2
XM9_f2 net023 VB3 VDD VDD sky130_fd_pr__pfet_01v8 w=0.5 l=1.2
XM9_f3 net023 VB3 VDD VDD sky130_fd_pr__pfet_01v8 w=0.5 l=1.2
XM10_f0 net021 VB3 VDD VDD sky130_fd_pr__pfet_01v8 w=0.5 l=1.2
XM10_f1 net021 VB3 VDD VDD sky130_fd_pr__pfet_01v8 w=0.5 l=1.2
XM10_f2 net021 VB3 VDD VDD sky130_fd_pr__pfet_01v8 w=0.5 l=1.2
XM10_f3 net021 VB3 VDD VDD sky130_fd_pr__pfet_01v8 w=0.5 l=1.2
.ends C10_sky130_sW0.5_sL2
