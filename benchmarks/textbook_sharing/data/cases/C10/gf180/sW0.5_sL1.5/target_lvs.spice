.subckt C10_gf180_sW0.5_sL1.5 VDD VSS VIN1 VIN2 VOUT1 VOUT2 VB1 VB2 VB3 VB4 IB1
MM1_f0 net022 VIN1 IB1 VDD pfet_03v3 w=0.5u l=0.84u
MM1_f1 net022 VIN1 IB1 VDD pfet_03v3 w=0.5u l=0.84u
MM1_f2 net022 VIN1 IB1 VDD pfet_03v3 w=0.5u l=0.84u
MM1_f3 net022 VIN1 IB1 VDD pfet_03v3 w=0.5u l=0.84u
MM2_f0 net018 VIN2 IB1 VDD pfet_03v3 w=0.5u l=0.84u
MM2_f1 net018 VIN2 IB1 VDD pfet_03v3 w=0.5u l=0.84u
MM2_f2 net018 VIN2 IB1 VDD pfet_03v3 w=0.5u l=0.84u
MM2_f3 net018 VIN2 IB1 VDD pfet_03v3 w=0.5u l=0.84u
MM3_f0 net022 VB4 VSS VSS nfet_03v3 w=0.5u l=0.84u
MM3_f1 net022 VB4 VSS VSS nfet_03v3 w=0.5u l=0.84u
MM3_f2 net022 VB4 VSS VSS nfet_03v3 w=0.5u l=0.84u
MM3_f3 net022 VB4 VSS VSS nfet_03v3 w=0.5u l=0.84u
MM4_f0 net018 VB4 VSS VSS nfet_03v3 w=0.5u l=0.84u
MM4_f1 net018 VB4 VSS VSS nfet_03v3 w=0.5u l=0.84u
MM4_f2 net018 VB4 VSS VSS nfet_03v3 w=0.5u l=0.84u
MM4_f3 net018 VB4 VSS VSS nfet_03v3 w=0.5u l=0.84u
MM5_f0 VOUT1 VB1 net022 VSS nfet_03v3 w=0.5u l=0.84u
MM5_f1 VOUT1 VB1 net022 VSS nfet_03v3 w=0.5u l=0.84u
MM5_f2 VOUT1 VB1 net022 VSS nfet_03v3 w=0.5u l=0.84u
MM5_f3 VOUT1 VB1 net022 VSS nfet_03v3 w=0.5u l=0.84u
MM6_f0 VOUT2 VB1 net018 VSS nfet_03v3 w=0.5u l=0.84u
MM6_f1 VOUT2 VB1 net018 VSS nfet_03v3 w=0.5u l=0.84u
MM6_f2 VOUT2 VB1 net018 VSS nfet_03v3 w=0.5u l=0.84u
MM6_f3 VOUT2 VB1 net018 VSS nfet_03v3 w=0.5u l=0.84u
MM7_f0 VOUT1 VB2 net023 VDD pfet_03v3 w=0.5u l=0.84u
MM7_f1 VOUT1 VB2 net023 VDD pfet_03v3 w=0.5u l=0.84u
MM7_f2 VOUT1 VB2 net023 VDD pfet_03v3 w=0.5u l=0.84u
MM7_f3 VOUT1 VB2 net023 VDD pfet_03v3 w=0.5u l=0.84u
MM8_f0 VOUT2 VB2 net021 VDD pfet_03v3 w=0.5u l=0.84u
MM8_f1 VOUT2 VB2 net021 VDD pfet_03v3 w=0.5u l=0.84u
MM8_f2 VOUT2 VB2 net021 VDD pfet_03v3 w=0.5u l=0.84u
MM8_f3 VOUT2 VB2 net021 VDD pfet_03v3 w=0.5u l=0.84u
MM9_f0 net023 VB3 VDD VDD pfet_03v3 w=0.5u l=0.84u
MM9_f1 net023 VB3 VDD VDD pfet_03v3 w=0.5u l=0.84u
MM9_f2 net023 VB3 VDD VDD pfet_03v3 w=0.5u l=0.84u
MM9_f3 net023 VB3 VDD VDD pfet_03v3 w=0.5u l=0.84u
MM10_f0 net021 VB3 VDD VDD pfet_03v3 w=0.5u l=0.84u
MM10_f1 net021 VB3 VDD VDD pfet_03v3 w=0.5u l=0.84u
MM10_f2 net021 VB3 VDD VDD pfet_03v3 w=0.5u l=0.84u
MM10_f3 net021 VB3 VDD VDD pfet_03v3 w=0.5u l=0.84u
.ends C10_gf180_sW0.5_sL1.5
