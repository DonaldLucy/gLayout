.subckt C10_gf180_sW1.5_sL2 VDD VSS VIN1 VIN2 VOUT1 VOUT2 VB1 VB2 VB3 VB4 IB1
MM1_f0 net022 VIN1 IB1 VDD pfet_03v3 w=0.5u l=1.12u
MM1_f1 net022 VIN1 IB1 VDD pfet_03v3 w=0.5u l=1.12u
MM1_f2 net022 VIN1 IB1 VDD pfet_03v3 w=0.5u l=1.12u
MM1_f3 net022 VIN1 IB1 VDD pfet_03v3 w=0.5u l=1.12u
MM1_f4 net022 VIN1 IB1 VDD pfet_03v3 w=0.5u l=1.12u
MM1_f5 net022 VIN1 IB1 VDD pfet_03v3 w=0.5u l=1.12u
MM1_f6 net022 VIN1 IB1 VDD pfet_03v3 w=0.5u l=1.12u
MM1_f7 net022 VIN1 IB1 VDD pfet_03v3 w=0.5u l=1.12u
MM1_f8 net022 VIN1 IB1 VDD pfet_03v3 w=0.5u l=1.12u
MM1_f9 net022 VIN1 IB1 VDD pfet_03v3 w=0.5u l=1.12u
MM1_f10 net022 VIN1 IB1 VDD pfet_03v3 w=0.5u l=1.12u
MM1_f11 net022 VIN1 IB1 VDD pfet_03v3 w=0.5u l=1.12u
MM2_f0 net018 VIN2 IB1 VDD pfet_03v3 w=0.5u l=1.12u
MM2_f1 net018 VIN2 IB1 VDD pfet_03v3 w=0.5u l=1.12u
MM2_f2 net018 VIN2 IB1 VDD pfet_03v3 w=0.5u l=1.12u
MM2_f3 net018 VIN2 IB1 VDD pfet_03v3 w=0.5u l=1.12u
MM2_f4 net018 VIN2 IB1 VDD pfet_03v3 w=0.5u l=1.12u
MM2_f5 net018 VIN2 IB1 VDD pfet_03v3 w=0.5u l=1.12u
MM2_f6 net018 VIN2 IB1 VDD pfet_03v3 w=0.5u l=1.12u
MM2_f7 net018 VIN2 IB1 VDD pfet_03v3 w=0.5u l=1.12u
MM2_f8 net018 VIN2 IB1 VDD pfet_03v3 w=0.5u l=1.12u
MM2_f9 net018 VIN2 IB1 VDD pfet_03v3 w=0.5u l=1.12u
MM2_f10 net018 VIN2 IB1 VDD pfet_03v3 w=0.5u l=1.12u
MM2_f11 net018 VIN2 IB1 VDD pfet_03v3 w=0.5u l=1.12u
MM3_f0 net022 VB4 VSS VSS nfet_03v3 w=0.5u l=1.12u
MM3_f1 net022 VB4 VSS VSS nfet_03v3 w=0.5u l=1.12u
MM3_f2 net022 VB4 VSS VSS nfet_03v3 w=0.5u l=1.12u
MM3_f3 net022 VB4 VSS VSS nfet_03v3 w=0.5u l=1.12u
MM3_f4 net022 VB4 VSS VSS nfet_03v3 w=0.5u l=1.12u
MM3_f5 net022 VB4 VSS VSS nfet_03v3 w=0.5u l=1.12u
MM3_f6 net022 VB4 VSS VSS nfet_03v3 w=0.5u l=1.12u
MM3_f7 net022 VB4 VSS VSS nfet_03v3 w=0.5u l=1.12u
MM3_f8 net022 VB4 VSS VSS nfet_03v3 w=0.5u l=1.12u
MM3_f9 net022 VB4 VSS VSS nfet_03v3 w=0.5u l=1.12u
MM3_f10 net022 VB4 VSS VSS nfet_03v3 w=0.5u l=1.12u
MM3_f11 net022 VB4 VSS VSS nfet_03v3 w=0.5u l=1.12u
MM4_f0 net018 VB4 VSS VSS nfet_03v3 w=0.5u l=1.12u
MM4_f1 net018 VB4 VSS VSS nfet_03v3 w=0.5u l=1.12u
MM4_f2 net018 VB4 VSS VSS nfet_03v3 w=0.5u l=1.12u
MM4_f3 net018 VB4 VSS VSS nfet_03v3 w=0.5u l=1.12u
MM4_f4 net018 VB4 VSS VSS nfet_03v3 w=0.5u l=1.12u
MM4_f5 net018 VB4 VSS VSS nfet_03v3 w=0.5u l=1.12u
MM4_f6 net018 VB4 VSS VSS nfet_03v3 w=0.5u l=1.12u
MM4_f7 net018 VB4 VSS VSS nfet_03v3 w=0.5u l=1.12u
MM4_f8 net018 VB4 VSS VSS nfet_03v3 w=0.5u l=1.12u
MM4_f9 net018 VB4 VSS VSS nfet_03v3 w=0.5u l=1.12u
MM4_f10 net018 VB4 VSS VSS nfet_03v3 w=0.5u l=1.12u
MM4_f11 net018 VB4 VSS VSS nfet_03v3 w=0.5u l=1.12u
MM5_f0 VOUT1 VB1 net022 VSS nfet_03v3 w=0.5u l=1.12u
MM5_f1 VOUT1 VB1 net022 VSS nfet_03v3 w=0.5u l=1.12u
MM5_f2 VOUT1 VB1 net022 VSS nfet_03v3 w=0.5u l=1.12u
MM5_f3 VOUT1 VB1 net022 VSS nfet_03v3 w=0.5u l=1.12u
MM5_f4 VOUT1 VB1 net022 VSS nfet_03v3 w=0.5u l=1.12u
MM5_f5 VOUT1 VB1 net022 VSS nfet_03v3 w=0.5u l=1.12u
MM5_f6 VOUT1 VB1 net022 VSS nfet_03v3 w=0.5u l=1.12u
MM5_f7 VOUT1 VB1 net022 VSS nfet_03v3 w=0.5u l=1.12u
MM5_f8 VOUT1 VB1 net022 VSS nfet_03v3 w=0.5u l=1.12u
MM5_f9 VOUT1 VB1 net022 VSS nfet_03v3 w=0.5u l=1.12u
MM5_f10 VOUT1 VB1 net022 VSS nfet_03v3 w=0.5u l=1.12u
MM5_f11 VOUT1 VB1 net022 VSS nfet_03v3 w=0.5u l=1.12u
MM6_f0 VOUT2 VB1 net018 VSS nfet_03v3 w=0.5u l=1.12u
MM6_f1 VOUT2 VB1 net018 VSS nfet_03v3 w=0.5u l=1.12u
MM6_f2 VOUT2 VB1 net018 VSS nfet_03v3 w=0.5u l=1.12u
MM6_f3 VOUT2 VB1 net018 VSS nfet_03v3 w=0.5u l=1.12u
MM6_f4 VOUT2 VB1 net018 VSS nfet_03v3 w=0.5u l=1.12u
MM6_f5 VOUT2 VB1 net018 VSS nfet_03v3 w=0.5u l=1.12u
MM6_f6 VOUT2 VB1 net018 VSS nfet_03v3 w=0.5u l=1.12u
MM6_f7 VOUT2 VB1 net018 VSS nfet_03v3 w=0.5u l=1.12u
MM6_f8 VOUT2 VB1 net018 VSS nfet_03v3 w=0.5u l=1.12u
MM6_f9 VOUT2 VB1 net018 VSS nfet_03v3 w=0.5u l=1.12u
MM6_f10 VOUT2 VB1 net018 VSS nfet_03v3 w=0.5u l=1.12u
MM6_f11 VOUT2 VB1 net018 VSS nfet_03v3 w=0.5u l=1.12u
MM7_f0 VOUT1 VB2 net023 VDD pfet_03v3 w=0.5u l=1.12u
MM7_f1 VOUT1 VB2 net023 VDD pfet_03v3 w=0.5u l=1.12u
MM7_f2 VOUT1 VB2 net023 VDD pfet_03v3 w=0.5u l=1.12u
MM7_f3 VOUT1 VB2 net023 VDD pfet_03v3 w=0.5u l=1.12u
MM7_f4 VOUT1 VB2 net023 VDD pfet_03v3 w=0.5u l=1.12u
MM7_f5 VOUT1 VB2 net023 VDD pfet_03v3 w=0.5u l=1.12u
MM7_f6 VOUT1 VB2 net023 VDD pfet_03v3 w=0.5u l=1.12u
MM7_f7 VOUT1 VB2 net023 VDD pfet_03v3 w=0.5u l=1.12u
MM7_f8 VOUT1 VB2 net023 VDD pfet_03v3 w=0.5u l=1.12u
MM7_f9 VOUT1 VB2 net023 VDD pfet_03v3 w=0.5u l=1.12u
MM7_f10 VOUT1 VB2 net023 VDD pfet_03v3 w=0.5u l=1.12u
MM7_f11 VOUT1 VB2 net023 VDD pfet_03v3 w=0.5u l=1.12u
MM8_f0 VOUT2 VB2 net021 VDD pfet_03v3 w=0.5u l=1.12u
MM8_f1 VOUT2 VB2 net021 VDD pfet_03v3 w=0.5u l=1.12u
MM8_f2 VOUT2 VB2 net021 VDD pfet_03v3 w=0.5u l=1.12u
MM8_f3 VOUT2 VB2 net021 VDD pfet_03v3 w=0.5u l=1.12u
MM8_f4 VOUT2 VB2 net021 VDD pfet_03v3 w=0.5u l=1.12u
MM8_f5 VOUT2 VB2 net021 VDD pfet_03v3 w=0.5u l=1.12u
MM8_f6 VOUT2 VB2 net021 VDD pfet_03v3 w=0.5u l=1.12u
MM8_f7 VOUT2 VB2 net021 VDD pfet_03v3 w=0.5u l=1.12u
MM8_f8 VOUT2 VB2 net021 VDD pfet_03v3 w=0.5u l=1.12u
MM8_f9 VOUT2 VB2 net021 VDD pfet_03v3 w=0.5u l=1.12u
MM8_f10 VOUT2 VB2 net021 VDD pfet_03v3 w=0.5u l=1.12u
MM8_f11 VOUT2 VB2 net021 VDD pfet_03v3 w=0.5u l=1.12u
MM9_f0 net023 VB3 VDD VDD pfet_03v3 w=0.5u l=1.12u
MM9_f1 net023 VB3 VDD VDD pfet_03v3 w=0.5u l=1.12u
MM9_f2 net023 VB3 VDD VDD pfet_03v3 w=0.5u l=1.12u
MM9_f3 net023 VB3 VDD VDD pfet_03v3 w=0.5u l=1.12u
MM9_f4 net023 VB3 VDD VDD pfet_03v3 w=0.5u l=1.12u
MM9_f5 net023 VB3 VDD VDD pfet_03v3 w=0.5u l=1.12u
MM9_f6 net023 VB3 VDD VDD pfet_03v3 w=0.5u l=1.12u
MM9_f7 net023 VB3 VDD VDD pfet_03v3 w=0.5u l=1.12u
MM9_f8 net023 VB3 VDD VDD pfet_03v3 w=0.5u l=1.12u
MM9_f9 net023 VB3 VDD VDD pfet_03v3 w=0.5u l=1.12u
MM9_f10 net023 VB3 VDD VDD pfet_03v3 w=0.5u l=1.12u
MM9_f11 net023 VB3 VDD VDD pfet_03v3 w=0.5u l=1.12u
MM10_f0 net021 VB3 VDD VDD pfet_03v3 w=0.5u l=1.12u
MM10_f1 net021 VB3 VDD VDD pfet_03v3 w=0.5u l=1.12u
MM10_f2 net021 VB3 VDD VDD pfet_03v3 w=0.5u l=1.12u
MM10_f3 net021 VB3 VDD VDD pfet_03v3 w=0.5u l=1.12u
MM10_f4 net021 VB3 VDD VDD pfet_03v3 w=0.5u l=1.12u
MM10_f5 net021 VB3 VDD VDD pfet_03v3 w=0.5u l=1.12u
MM10_f6 net021 VB3 VDD VDD pfet_03v3 w=0.5u l=1.12u
MM10_f7 net021 VB3 VDD VDD pfet_03v3 w=0.5u l=1.12u
MM10_f8 net021 VB3 VDD VDD pfet_03v3 w=0.5u l=1.12u
MM10_f9 net021 VB3 VDD VDD pfet_03v3 w=0.5u l=1.12u
MM10_f10 net021 VB3 VDD VDD pfet_03v3 w=0.5u l=1.12u
MM10_f11 net021 VB3 VDD VDD pfet_03v3 w=0.5u l=1.12u
.ends C10_gf180_sW1.5_sL2
