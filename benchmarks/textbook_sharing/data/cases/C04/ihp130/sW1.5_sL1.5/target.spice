.subckt C04_ihp130_sW1.5_sL1.5 VDD VSS VIN1 VOUT1 VB1
XM1 VOUT1 VB1 VDD VDD sg13_lv_pmos w=6u l=0.39u ng=12 m=1
XM2 VOUT1 VIN1 VSS VSS sg13_lv_nmos w=3u l=0.39u ng=6 m=1
.ends C04_ihp130_sW1.5_sL1.5
