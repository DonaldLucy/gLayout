.subckt C04_ihp130_sW1.5_sL1 VDD VSS VIN1 VOUT1 VB1
XM1_f0 VOUT1 VB1 VDD VDD sg13_lv_pmos w=0.5u l=0.26u
XM1_f1 VOUT1 VB1 VDD VDD sg13_lv_pmos w=0.5u l=0.26u
XM1_f2 VOUT1 VB1 VDD VDD sg13_lv_pmos w=0.5u l=0.26u
XM1_f3 VOUT1 VB1 VDD VDD sg13_lv_pmos w=0.5u l=0.26u
XM1_f4 VOUT1 VB1 VDD VDD sg13_lv_pmos w=0.5u l=0.26u
XM1_f5 VOUT1 VB1 VDD VDD sg13_lv_pmos w=0.5u l=0.26u
XM1_f6 VOUT1 VB1 VDD VDD sg13_lv_pmos w=0.5u l=0.26u
XM1_f7 VOUT1 VB1 VDD VDD sg13_lv_pmos w=0.5u l=0.26u
XM1_f8 VOUT1 VB1 VDD VDD sg13_lv_pmos w=0.5u l=0.26u
XM1_f9 VOUT1 VB1 VDD VDD sg13_lv_pmos w=0.5u l=0.26u
XM1_f10 VOUT1 VB1 VDD VDD sg13_lv_pmos w=0.5u l=0.26u
XM1_f11 VOUT1 VB1 VDD VDD sg13_lv_pmos w=0.5u l=0.26u
XM2_f0 VOUT1 VIN1 VSS VSS sg13_lv_nmos w=0.5u l=0.26u
XM2_f1 VOUT1 VIN1 VSS VSS sg13_lv_nmos w=0.5u l=0.26u
XM2_f2 VOUT1 VIN1 VSS VSS sg13_lv_nmos w=0.5u l=0.26u
XM2_f3 VOUT1 VIN1 VSS VSS sg13_lv_nmos w=0.5u l=0.26u
XM2_f4 VOUT1 VIN1 VSS VSS sg13_lv_nmos w=0.5u l=0.26u
XM2_f5 VOUT1 VIN1 VSS VSS sg13_lv_nmos w=0.5u l=0.26u
.ends C04_ihp130_sW1.5_sL1
