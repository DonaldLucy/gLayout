.subckt C04_ihp130_sW0.5_sL1.5 VDD VSS VIN1 VOUT1 VB1
XM1_f0 VOUT1 VB1 VDD VDD sg13_lv_pmos w=0.5u l=0.39u
XM1_f1 VOUT1 VB1 VDD VDD sg13_lv_pmos w=0.5u l=0.39u
XM1_f2 VOUT1 VB1 VDD VDD sg13_lv_pmos w=0.5u l=0.39u
XM1_f3 VOUT1 VB1 VDD VDD sg13_lv_pmos w=0.5u l=0.39u
XM2_f0 VOUT1 VIN1 VSS VSS sg13_lv_nmos w=0.5u l=0.39u
XM2_f1 VOUT1 VIN1 VSS VSS sg13_lv_nmos w=0.5u l=0.39u
.ends C04_ihp130_sW0.5_sL1.5
