.subckt C04_gf180_sW1.5_sL1 VDD VSS VIN1 VOUT1 VB1
MM1 VOUT1 VB1 VDD VDD pfet_03v3 w=6u l=0.56u nf=12 m=1
MM2 VOUT1 VIN1 VSS VSS nfet_03v3 w=3u l=0.56u nf=6 m=1
.ends C04_gf180_sW1.5_sL1
