.subckt C04_gf180_sW0.5_sL1 VDD VSS VIN1 VOUT1 VB1
MM1_f0 VOUT1 VB1 VDD VDD pfet_03v3 w=0.5u l=0.56u
MM1_f1 VOUT1 VB1 VDD VDD pfet_03v3 w=0.5u l=0.56u
MM1_f2 VOUT1 VB1 VDD VDD pfet_03v3 w=0.5u l=0.56u
MM1_f3 VOUT1 VB1 VDD VDD pfet_03v3 w=0.5u l=0.56u
MM2_f0 VOUT1 VIN1 VSS VSS nfet_03v3 w=0.5u l=0.56u
MM2_f1 VOUT1 VIN1 VSS VSS nfet_03v3 w=0.5u l=0.56u
.ends C04_gf180_sW0.5_sL1
