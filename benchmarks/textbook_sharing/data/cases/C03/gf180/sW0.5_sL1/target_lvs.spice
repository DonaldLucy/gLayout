.subckt C03_gf180_sW0.5_sL1 VSS IIN1 IOUT1
MM1_f0 IIN1 Y VSS VSS nfet_03v3 w=0.5u l=2.24u
MM1_f1 IIN1 Y VSS VSS nfet_03v3 w=0.5u l=2.24u
MM1_f2 IIN1 Y VSS VSS nfet_03v3 w=0.5u l=2.24u
MM1_f3 IIN1 Y VSS VSS nfet_03v3 w=0.5u l=2.24u
MM2_f0 Y Y VSS VSS nfet_03v3 w=0.5u l=2.24u
MM2_f1 Y Y VSS VSS nfet_03v3 w=0.5u l=2.24u
MM2_f2 Y Y VSS VSS nfet_03v3 w=0.5u l=2.24u
MM2_f3 Y Y VSS VSS nfet_03v3 w=0.5u l=2.24u
MM3_f0 IOUT1 IIN1 Y VSS nfet_03v3 w=0.5u l=2.24u
MM3_f1 IOUT1 IIN1 Y VSS nfet_03v3 w=0.5u l=2.24u
MM3_f2 IOUT1 IIN1 Y VSS nfet_03v3 w=0.5u l=2.24u
MM3_f3 IOUT1 IIN1 Y VSS nfet_03v3 w=0.5u l=2.24u
.ends C03_gf180_sW0.5_sL1
