.subckt C03_gf180_sW1_sL1 VSS IIN1 IOUT1
MM1_f0 IIN1 Y VSS VSS nfet_03v3 w=0.5u l=2.24u
MM1_f1 IIN1 Y VSS VSS nfet_03v3 w=0.5u l=2.24u
MM1_f2 IIN1 Y VSS VSS nfet_03v3 w=0.5u l=2.24u
MM1_f3 IIN1 Y VSS VSS nfet_03v3 w=0.5u l=2.24u
MM1_f4 IIN1 Y VSS VSS nfet_03v3 w=0.5u l=2.24u
MM1_f5 IIN1 Y VSS VSS nfet_03v3 w=0.5u l=2.24u
MM1_f6 IIN1 Y VSS VSS nfet_03v3 w=0.5u l=2.24u
MM1_f7 IIN1 Y VSS VSS nfet_03v3 w=0.5u l=2.24u
MM2_f0 Y Y VSS VSS nfet_03v3 w=0.5u l=2.24u
MM2_f1 Y Y VSS VSS nfet_03v3 w=0.5u l=2.24u
MM2_f2 Y Y VSS VSS nfet_03v3 w=0.5u l=2.24u
MM2_f3 Y Y VSS VSS nfet_03v3 w=0.5u l=2.24u
MM2_f4 Y Y VSS VSS nfet_03v3 w=0.5u l=2.24u
MM2_f5 Y Y VSS VSS nfet_03v3 w=0.5u l=2.24u
MM2_f6 Y Y VSS VSS nfet_03v3 w=0.5u l=2.24u
MM2_f7 Y Y VSS VSS nfet_03v3 w=0.5u l=2.24u
MM3_f0 IOUT1 IIN1 Y VSS nfet_03v3 w=0.5u l=2.24u
MM3_f1 IOUT1 IIN1 Y VSS nfet_03v3 w=0.5u l=2.24u
MM3_f2 IOUT1 IIN1 Y VSS nfet_03v3 w=0.5u l=2.24u
MM3_f3 IOUT1 IIN1 Y VSS nfet_03v3 w=0.5u l=2.24u
MM3_f4 IOUT1 IIN1 Y VSS nfet_03v3 w=0.5u l=2.24u
MM3_f5 IOUT1 IIN1 Y VSS nfet_03v3 w=0.5u l=2.24u
MM3_f6 IOUT1 IIN1 Y VSS nfet_03v3 w=0.5u l=2.24u
MM3_f7 IOUT1 IIN1 Y VSS nfet_03v3 w=0.5u l=2.24u
.ends C03_gf180_sW1_sL1
