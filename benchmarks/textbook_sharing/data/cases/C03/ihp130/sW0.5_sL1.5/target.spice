.subckt C03_ihp130_sW0.5_sL1.5 VSS IIN1 IOUT1
XM1 IIN1 Y VSS VSS sg13_lv_nmos w=2u l=3.12u ng=4 m=1
XM2 Y Y VSS VSS sg13_lv_nmos w=2u l=3.12u ng=4 m=1
XM3 IOUT1 IIN1 Y VSS sg13_lv_nmos w=2u l=3.12u ng=4 m=1
.ends C03_ihp130_sW0.5_sL1.5
