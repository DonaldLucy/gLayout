.subckt C08_ihp130_sW0.5_sL1 VDD VSS VIN1 VIN2 VOUT1 VB1
XM1_f0 net22 VIN1 net23 VSS sg13_lv_nmos w=0.5u l=0.39u
XM1_f1 net22 VIN1 net23 VSS sg13_lv_nmos w=0.5u l=0.39u
XM1_f2 net22 VIN1 net23 VSS sg13_lv_nmos w=0.5u l=0.39u
XM1_f3 net22 VIN1 net23 VSS sg13_lv_nmos w=0.5u l=0.39u
XM2_f0 VOUT1 VIN2 net23 VSS sg13_lv_nmos w=0.5u l=0.39u
XM2_f1 VOUT1 VIN2 net23 VSS sg13_lv_nmos w=0.5u l=0.39u
XM2_f2 VOUT1 VIN2 net23 VSS sg13_lv_nmos w=0.5u l=0.39u
XM2_f3 VOUT1 VIN2 net23 VSS sg13_lv_nmos w=0.5u l=0.39u
XM3_f0 net23 VB1 VSS VSS sg13_lv_nmos w=0.5u l=0.39u
XM3_f1 net23 VB1 VSS VSS sg13_lv_nmos w=0.5u l=0.39u
XM3_f2 net23 VB1 VSS VSS sg13_lv_nmos w=0.5u l=0.39u
XM3_f3 net23 VB1 VSS VSS sg13_lv_nmos w=0.5u l=0.39u
XM4_f0 net22 net22 VDD VDD sg13_lv_pmos w=0.5u l=0.39u
XM4_f1 net22 net22 VDD VDD sg13_lv_pmos w=0.5u l=0.39u
XM5_f0 VOUT1 net22 VDD VDD sg13_lv_pmos w=0.5u l=0.39u
XM5_f1 VOUT1 net22 VDD VDD sg13_lv_pmos w=0.5u l=0.39u
.ends C08_ihp130_sW0.5_sL1
