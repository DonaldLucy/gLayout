.subckt C08_sky130_sW0.5_sL1.5 VDD VSS VIN1 VIN2 VOUT1 VB1
XM1 net22 VIN1 net23 VSS sky130_fd_pr__nfet_01v8 w=2 l=0.45 nf=4
XM2 VOUT1 VIN2 net23 VSS sky130_fd_pr__nfet_01v8 w=2 l=0.45 nf=4
XM3 net23 VB1 VSS VSS sky130_fd_pr__nfet_01v8 w=2 l=0.45 nf=4
XM4 net22 net22 VDD VDD sky130_fd_pr__pfet_01v8 w=1 l=0.45 nf=2
XM5 VOUT1 net22 VDD VDD sky130_fd_pr__pfet_01v8 w=1 l=0.45 nf=2
.ends C08_sky130_sW0.5_sL1.5
