.subckt C08_gf180_sW1_sL1 VDD VSS VIN1 VIN2 VOUT1 VB1
MM1_f0 net22 VIN1 net23 VSS nfet_03v3 w=0.5u l=0.56u
MM1_f1 net22 VIN1 net23 VSS nfet_03v3 w=0.5u l=0.56u
MM1_f2 net22 VIN1 net23 VSS nfet_03v3 w=0.5u l=0.56u
MM1_f3 net22 VIN1 net23 VSS nfet_03v3 w=0.5u l=0.56u
MM1_f4 net22 VIN1 net23 VSS nfet_03v3 w=0.5u l=0.56u
MM1_f5 net22 VIN1 net23 VSS nfet_03v3 w=0.5u l=0.56u
MM1_f6 net22 VIN1 net23 VSS nfet_03v3 w=0.5u l=0.56u
MM1_f7 net22 VIN1 net23 VSS nfet_03v3 w=0.5u l=0.56u
MM2_f0 VOUT1 VIN2 net23 VSS nfet_03v3 w=0.5u l=0.56u
MM2_f1 VOUT1 VIN2 net23 VSS nfet_03v3 w=0.5u l=0.56u
MM2_f2 VOUT1 VIN2 net23 VSS nfet_03v3 w=0.5u l=0.56u
MM2_f3 VOUT1 VIN2 net23 VSS nfet_03v3 w=0.5u l=0.56u
MM2_f4 VOUT1 VIN2 net23 VSS nfet_03v3 w=0.5u l=0.56u
MM2_f5 VOUT1 VIN2 net23 VSS nfet_03v3 w=0.5u l=0.56u
MM2_f6 VOUT1 VIN2 net23 VSS nfet_03v3 w=0.5u l=0.56u
MM2_f7 VOUT1 VIN2 net23 VSS nfet_03v3 w=0.5u l=0.56u
MM3_f0 net23 VB1 VSS VSS nfet_03v3 w=0.5u l=0.56u
MM3_f1 net23 VB1 VSS VSS nfet_03v3 w=0.5u l=0.56u
MM3_f2 net23 VB1 VSS VSS nfet_03v3 w=0.5u l=0.56u
MM3_f3 net23 VB1 VSS VSS nfet_03v3 w=0.5u l=0.56u
MM3_f4 net23 VB1 VSS VSS nfet_03v3 w=0.5u l=0.56u
MM3_f5 net23 VB1 VSS VSS nfet_03v3 w=0.5u l=0.56u
MM3_f6 net23 VB1 VSS VSS nfet_03v3 w=0.5u l=0.56u
MM3_f7 net23 VB1 VSS VSS nfet_03v3 w=0.5u l=0.56u
MM4_f0 net22 net22 VDD VDD pfet_03v3 w=0.5u l=0.56u
MM4_f1 net22 net22 VDD VDD pfet_03v3 w=0.5u l=0.56u
MM4_f2 net22 net22 VDD VDD pfet_03v3 w=0.5u l=0.56u
MM4_f3 net22 net22 VDD VDD pfet_03v3 w=0.5u l=0.56u
MM5_f0 VOUT1 net22 VDD VDD pfet_03v3 w=0.5u l=0.56u
MM5_f1 VOUT1 net22 VDD VDD pfet_03v3 w=0.5u l=0.56u
MM5_f2 VOUT1 net22 VDD VDD pfet_03v3 w=0.5u l=0.56u
MM5_f3 VOUT1 net22 VDD VDD pfet_03v3 w=0.5u l=0.56u
.ends C08_gf180_sW1_sL1
