X1 VDD VSS VIN1 VIN2 VOUT1 VB1 C08_gf180_sW1.5_sL1
.include DUT_INCLUDE_PATH
VDD VDD 0 3.3
VSS VSS 0 0
VDDB VDDB 0 3.3
MB_VB1 VB1 VB1 VSS VSS nfet_03v3 w=6u l=0.56u
IB_VB1 VDDB VB1 4e-05
VCM VCM 0 1.5
* DC servo (disclosed): VINT = 0.5 tanh(2e4 (VOUT1 - VT)) (bounded to +-0.5 V), low-passed at 0.16 uHz, sets the inverting input DC level
VT VT 0 1.65
BSRV VSRV 0 V = 0.5*tanh(2e4*(v(VOUT1)-v(VT)))
RSRV VSRV VINT 1e3
CSRV VINT 0 1e3
EINV VIN2 VCM VINT 0 1
EIN VIN1 VCM VD 0 1
VD VD 0 dc 0 ac 1
CL VOUT1 0 1e-12
.control
op
let vout0 = v(VOUT1)
let idd = -i(VDD)
let vos = v(VIN2) - v(VIN1)
print vout0 idd vos
print v(VCM)
ac dec 20 10 100G
let gdb = db(v(VOUT1))
let ph = cph(v(VOUT1))*180/pi
meas ac gain_lf find gdb at=100
meas ac ph_lf find ph at=100
meas ac ugf when gdb=0 cross=1
meas ac ph_ugf find ph when gdb=0 cross=1
let g3 = gdb - gain_lf + 3
meas ac f3db when g3=0 cross=1
quit
.endc
.end
