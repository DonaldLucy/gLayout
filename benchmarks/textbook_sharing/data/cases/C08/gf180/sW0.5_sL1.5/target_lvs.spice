.subckt C08_gf180_sW0.5_sL1.5 VDD VSS VIN1 VIN2 VOUT1 VB1
MM1_f0 net22 VIN1 net23 VSS nfet_03v3 w=0.5u l=0.84u
MM1_f1 net22 VIN1 net23 VSS nfet_03v3 w=0.5u l=0.84u
MM1_f2 net22 VIN1 net23 VSS nfet_03v3 w=0.5u l=0.84u
MM1_f3 net22 VIN1 net23 VSS nfet_03v3 w=0.5u l=0.84u
MM2_f0 VOUT1 VIN2 net23 VSS nfet_03v3 w=0.5u l=0.84u
MM2_f1 VOUT1 VIN2 net23 VSS nfet_03v3 w=0.5u l=0.84u
MM2_f2 VOUT1 VIN2 net23 VSS nfet_03v3 w=0.5u l=0.84u
MM2_f3 VOUT1 VIN2 net23 VSS nfet_03v3 w=0.5u l=0.84u
MM3_f0 net23 VB1 VSS VSS nfet_03v3 w=0.5u l=0.84u
MM3_f1 net23 VB1 VSS VSS nfet_03v3 w=0.5u l=0.84u
MM3_f2 net23 VB1 VSS VSS nfet_03v3 w=0.5u l=0.84u
MM3_f3 net23 VB1 VSS VSS nfet_03v3 w=0.5u l=0.84u
MM4_f0 net22 net22 VDD VDD pfet_03v3 w=0.5u l=0.84u
MM4_f1 net22 net22 VDD VDD pfet_03v3 w=0.5u l=0.84u
MM5_f0 VOUT1 net22 VDD VDD pfet_03v3 w=0.5u l=0.84u
MM5_f1 VOUT1 net22 VDD VDD pfet_03v3 w=0.5u l=0.84u
.ends C08_gf180_sW0.5_sL1.5
