.subckt C07_ihp130_sW0.5_sL2 VDD VSS VIN1 VIN2 VOUT1 VOUT2 VB1 IB1
XM1_f0 VOUT1 VIN1 IB1 VSS sg13_lv_nmos w=0.5u l=0.52u
XM1_f1 VOUT1 VIN1 IB1 VSS sg13_lv_nmos w=0.5u l=0.52u
XM1_f2 VOUT1 VIN1 IB1 VSS sg13_lv_nmos w=0.5u l=0.52u
XM1_f3 VOUT1 VIN1 IB1 VSS sg13_lv_nmos w=0.5u l=0.52u
XM2_f0 VOUT2 VIN2 IB1 VSS sg13_lv_nmos w=0.5u l=0.52u
XM2_f1 VOUT2 VIN2 IB1 VSS sg13_lv_nmos w=0.5u l=0.52u
XM2_f2 VOUT2 VIN2 IB1 VSS sg13_lv_nmos w=0.5u l=0.52u
XM2_f3 VOUT2 VIN2 IB1 VSS sg13_lv_nmos w=0.5u l=0.52u
XM3_f0 VOUT1 VB1 VDD VDD sg13_lv_pmos w=0.5u l=0.52u
XM3_f1 VOUT1 VB1 VDD VDD sg13_lv_pmos w=0.5u l=0.52u
XM3_f2 VOUT1 VB1 VDD VDD sg13_lv_pmos w=0.5u l=0.52u
XM3_f3 VOUT1 VB1 VDD VDD sg13_lv_pmos w=0.5u l=0.52u
XM4_f0 VOUT2 VB1 VDD VDD sg13_lv_pmos w=0.5u l=0.52u
XM4_f1 VOUT2 VB1 VDD VDD sg13_lv_pmos w=0.5u l=0.52u
XM4_f2 VOUT2 VB1 VDD VDD sg13_lv_pmos w=0.5u l=0.52u
XM4_f3 VOUT2 VB1 VDD VDD sg13_lv_pmos w=0.5u l=0.52u
.ends C07_ihp130_sW0.5_sL2
