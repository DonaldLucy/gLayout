.subckt C07_ihp130_sW1.5_sL1.5 VDD VSS VIN1 VIN2 VOUT1 VOUT2 VB1 IB1
XM1_f0 VOUT1 VIN1 IB1 VSS sg13_lv_nmos w=0.5u l=0.39u
XM1_f1 VOUT1 VIN1 IB1 VSS sg13_lv_nmos w=0.5u l=0.39u
XM1_f2 VOUT1 VIN1 IB1 VSS sg13_lv_nmos w=0.5u l=0.39u
XM1_f3 VOUT1 VIN1 IB1 VSS sg13_lv_nmos w=0.5u l=0.39u
XM1_f4 VOUT1 VIN1 IB1 VSS sg13_lv_nmos w=0.5u l=0.39u
XM1_f5 VOUT1 VIN1 IB1 VSS sg13_lv_nmos w=0.5u l=0.39u
XM1_f6 VOUT1 VIN1 IB1 VSS sg13_lv_nmos w=0.5u l=0.39u
XM1_f7 VOUT1 VIN1 IB1 VSS sg13_lv_nmos w=0.5u l=0.39u
XM1_f8 VOUT1 VIN1 IB1 VSS sg13_lv_nmos w=0.5u l=0.39u
XM1_f9 VOUT1 VIN1 IB1 VSS sg13_lv_nmos w=0.5u l=0.39u
XM1_f10 VOUT1 VIN1 IB1 VSS sg13_lv_nmos w=0.5u l=0.39u
XM1_f11 VOUT1 VIN1 IB1 VSS sg13_lv_nmos w=0.5u l=0.39u
XM2_f0 VOUT2 VIN2 IB1 VSS sg13_lv_nmos w=0.5u l=0.39u
XM2_f1 VOUT2 VIN2 IB1 VSS sg13_lv_nmos w=0.5u l=0.39u
XM2_f2 VOUT2 VIN2 IB1 VSS sg13_lv_nmos w=0.5u l=0.39u
XM2_f3 VOUT2 VIN2 IB1 VSS sg13_lv_nmos w=0.5u l=0.39u
XM2_f4 VOUT2 VIN2 IB1 VSS sg13_lv_nmos w=0.5u l=0.39u
XM2_f5 VOUT2 VIN2 IB1 VSS sg13_lv_nmos w=0.5u l=0.39u
XM2_f6 VOUT2 VIN2 IB1 VSS sg13_lv_nmos w=0.5u l=0.39u
XM2_f7 VOUT2 VIN2 IB1 VSS sg13_lv_nmos w=0.5u l=0.39u
XM2_f8 VOUT2 VIN2 IB1 VSS sg13_lv_nmos w=0.5u l=0.39u
XM2_f9 VOUT2 VIN2 IB1 VSS sg13_lv_nmos w=0.5u l=0.39u
XM2_f10 VOUT2 VIN2 IB1 VSS sg13_lv_nmos w=0.5u l=0.39u
XM2_f11 VOUT2 VIN2 IB1 VSS sg13_lv_nmos w=0.5u l=0.39u
XM3_f0 VOUT1 VB1 VDD VDD sg13_lv_pmos w=0.5u l=0.39u
XM3_f1 VOUT1 VB1 VDD VDD sg13_lv_pmos w=0.5u l=0.39u
XM3_f2 VOUT1 VB1 VDD VDD sg13_lv_pmos w=0.5u l=0.39u
XM3_f3 VOUT1 VB1 VDD VDD sg13_lv_pmos w=0.5u l=0.39u
XM3_f4 VOUT1 VB1 VDD VDD sg13_lv_pmos w=0.5u l=0.39u
XM3_f5 VOUT1 VB1 VDD VDD sg13_lv_pmos w=0.5u l=0.39u
XM3_f6 VOUT1 VB1 VDD VDD sg13_lv_pmos w=0.5u l=0.39u
XM3_f7 VOUT1 VB1 VDD VDD sg13_lv_pmos w=0.5u l=0.39u
XM3_f8 VOUT1 VB1 VDD VDD sg13_lv_pmos w=0.5u l=0.39u
XM3_f9 VOUT1 VB1 VDD VDD sg13_lv_pmos w=0.5u l=0.39u
XM3_f10 VOUT1 VB1 VDD VDD sg13_lv_pmos w=0.5u l=0.39u
XM3_f11 VOUT1 VB1 VDD VDD sg13_lv_pmos w=0.5u l=0.39u
XM4_f0 VOUT2 VB1 VDD VDD sg13_lv_pmos w=0.5u l=0.39u
XM4_f1 VOUT2 VB1 VDD VDD sg13_lv_pmos w=0.5u l=0.39u
XM4_f2 VOUT2 VB1 VDD VDD sg13_lv_pmos w=0.5u l=0.39u
XM4_f3 VOUT2 VB1 VDD VDD sg13_lv_pmos w=0.5u l=0.39u
XM4_f4 VOUT2 VB1 VDD VDD sg13_lv_pmos w=0.5u l=0.39u
XM4_f5 VOUT2 VB1 VDD VDD sg13_lv_pmos w=0.5u l=0.39u
XM4_f6 VOUT2 VB1 VDD VDD sg13_lv_pmos w=0.5u l=0.39u
XM4_f7 VOUT2 VB1 VDD VDD sg13_lv_pmos w=0.5u l=0.39u
XM4_f8 VOUT2 VB1 VDD VDD sg13_lv_pmos w=0.5u l=0.39u
XM4_f9 VOUT2 VB1 VDD VDD sg13_lv_pmos w=0.5u l=0.39u
XM4_f10 VOUT2 VB1 VDD VDD sg13_lv_pmos w=0.5u l=0.39u
XM4_f11 VOUT2 VB1 VDD VDD sg13_lv_pmos w=0.5u l=0.39u
.ends C07_ihp130_sW1.5_sL1.5
