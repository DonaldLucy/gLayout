.subckt C07_ihp130_sW1_sL1.5 VDD VSS VIN1 VIN2 VOUT1 VOUT2 VB1 IB1
XM1 VOUT1 VIN1 IB1 VSS sg13_lv_nmos w=4u l=0.39u ng=8 m=1
XM2 VOUT2 VIN2 IB1 VSS sg13_lv_nmos w=4u l=0.39u ng=8 m=1
XM3 VOUT1 VB1 VDD VDD sg13_lv_pmos w=4u l=0.39u ng=8 m=1
XM4 VOUT2 VB1 VDD VDD sg13_lv_pmos w=4u l=0.39u ng=8 m=1
.ends C07_ihp130_sW1_sL1.5
