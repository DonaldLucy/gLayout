.subckt C07_gf180_sW1.5_sL1.5 VDD VSS VIN1 VIN2 VOUT1 VOUT2 VB1 IB1
MM1 VOUT1 VIN1 IB1 VSS nfet_03v3 w=6u l=0.84u nf=12 m=1
MM2 VOUT2 VIN2 IB1 VSS nfet_03v3 w=6u l=0.84u nf=12 m=1
MM3 VOUT1 VB1 VDD VDD pfet_03v3 w=6u l=0.84u nf=12 m=1
MM4 VOUT2 VB1 VDD VDD pfet_03v3 w=6u l=0.84u nf=12 m=1
.ends C07_gf180_sW1.5_sL1.5
