.subckt C07_gf180_sW2_sL1.5 VDD VSS VIN1 VIN2 VOUT1 VOUT2 VB1 IB1
MM1_f0 VOUT1 VIN1 IB1 VSS nfet_03v3 w=0.5u l=0.84u
MM1_f1 VOUT1 VIN1 IB1 VSS nfet_03v3 w=0.5u l=0.84u
MM1_f2 VOUT1 VIN1 IB1 VSS nfet_03v3 w=0.5u l=0.84u
MM1_f3 VOUT1 VIN1 IB1 VSS nfet_03v3 w=0.5u l=0.84u
MM1_f4 VOUT1 VIN1 IB1 VSS nfet_03v3 w=0.5u l=0.84u
MM1_f5 VOUT1 VIN1 IB1 VSS nfet_03v3 w=0.5u l=0.84u
MM1_f6 VOUT1 VIN1 IB1 VSS nfet_03v3 w=0.5u l=0.84u
MM1_f7 VOUT1 VIN1 IB1 VSS nfet_03v3 w=0.5u l=0.84u
MM1_f8 VOUT1 VIN1 IB1 VSS nfet_03v3 w=0.5u l=0.84u
MM1_f9 VOUT1 VIN1 IB1 VSS nfet_03v3 w=0.5u l=0.84u
MM1_f10 VOUT1 VIN1 IB1 VSS nfet_03v3 w=0.5u l=0.84u
MM1_f11 VOUT1 VIN1 IB1 VSS nfet_03v3 w=0.5u l=0.84u
MM1_f12 VOUT1 VIN1 IB1 VSS nfet_03v3 w=0.5u l=0.84u
MM1_f13 VOUT1 VIN1 IB1 VSS nfet_03v3 w=0.5u l=0.84u
MM1_f14 VOUT1 VIN1 IB1 VSS nfet_03v3 w=0.5u l=0.84u
MM1_f15 VOUT1 VIN1 IB1 VSS nfet_03v3 w=0.5u l=0.84u
MM2_f0 VOUT2 VIN2 IB1 VSS nfet_03v3 w=0.5u l=0.84u
MM2_f1 VOUT2 VIN2 IB1 VSS nfet_03v3 w=0.5u l=0.84u
MM2_f2 VOUT2 VIN2 IB1 VSS nfet_03v3 w=0.5u l=0.84u
MM2_f3 VOUT2 VIN2 IB1 VSS nfet_03v3 w=0.5u l=0.84u
MM2_f4 VOUT2 VIN2 IB1 VSS nfet_03v3 w=0.5u l=0.84u
MM2_f5 VOUT2 VIN2 IB1 VSS nfet_03v3 w=0.5u l=0.84u
MM2_f6 VOUT2 VIN2 IB1 VSS nfet_03v3 w=0.5u l=0.84u
MM2_f7 VOUT2 VIN2 IB1 VSS nfet_03v3 w=0.5u l=0.84u
MM2_f8 VOUT2 VIN2 IB1 VSS nfet_03v3 w=0.5u l=0.84u
MM2_f9 VOUT2 VIN2 IB1 VSS nfet_03v3 w=0.5u l=0.84u
MM2_f10 VOUT2 VIN2 IB1 VSS nfet_03v3 w=0.5u l=0.84u
MM2_f11 VOUT2 VIN2 IB1 VSS nfet_03v3 w=0.5u l=0.84u
MM2_f12 VOUT2 VIN2 IB1 VSS nfet_03v3 w=0.5u l=0.84u
MM2_f13 VOUT2 VIN2 IB1 VSS nfet_03v3 w=0.5u l=0.84u
MM2_f14 VOUT2 VIN2 IB1 VSS nfet_03v3 w=0.5u l=0.84u
MM2_f15 VOUT2 VIN2 IB1 VSS nfet_03v3 w=0.5u l=0.84u
MM3_f0 VOUT1 VB1 VDD VDD pfet_03v3 w=0.5u l=0.84u
MM3_f1 VOUT1 VB1 VDD VDD pfet_03v3 w=0.5u l=0.84u
MM3_f2 VOUT1 VB1 VDD VDD pfet_03v3 w=0.5u l=0.84u
MM3_f3 VOUT1 VB1 VDD VDD pfet_03v3 w=0.5u l=0.84u
MM3_f4 VOUT1 VB1 VDD VDD pfet_03v3 w=0.5u l=0.84u
MM3_f5 VOUT1 VB1 VDD VDD pfet_03v3 w=0.5u l=0.84u
MM3_f6 VOUT1 VB1 VDD VDD pfet_03v3 w=0.5u l=0.84u
MM3_f7 VOUT1 VB1 VDD VDD pfet_03v3 w=0.5u l=0.84u
MM3_f8 VOUT1 VB1 VDD VDD pfet_03v3 w=0.5u l=0.84u
MM3_f9 VOUT1 VB1 VDD VDD pfet_03v3 w=0.5u l=0.84u
MM3_f10 VOUT1 VB1 VDD VDD pfet_03v3 w=0.5u l=0.84u
MM3_f11 VOUT1 VB1 VDD VDD pfet_03v3 w=0.5u l=0.84u
MM3_f12 VOUT1 VB1 VDD VDD pfet_03v3 w=0.5u l=0.84u
MM3_f13 VOUT1 VB1 VDD VDD pfet_03v3 w=0.5u l=0.84u
MM3_f14 VOUT1 VB1 VDD VDD pfet_03v3 w=0.5u l=0.84u
MM3_f15 VOUT1 VB1 VDD VDD pfet_03v3 w=0.5u l=0.84u
MM4_f0 VOUT2 VB1 VDD VDD pfet_03v3 w=0.5u l=0.84u
MM4_f1 VOUT2 VB1 VDD VDD pfet_03v3 w=0.5u l=0.84u
MM4_f2 VOUT2 VB1 VDD VDD pfet_03v3 w=0.5u l=0.84u
MM4_f3 VOUT2 VB1 VDD VDD pfet_03v3 w=0.5u l=0.84u
MM4_f4 VOUT2 VB1 VDD VDD pfet_03v3 w=0.5u l=0.84u
MM4_f5 VOUT2 VB1 VDD VDD pfet_03v3 w=0.5u l=0.84u
MM4_f6 VOUT2 VB1 VDD VDD pfet_03v3 w=0.5u l=0.84u
MM4_f7 VOUT2 VB1 VDD VDD pfet_03v3 w=0.5u l=0.84u
MM4_f8 VOUT2 VB1 VDD VDD pfet_03v3 w=0.5u l=0.84u
MM4_f9 VOUT2 VB1 VDD VDD pfet_03v3 w=0.5u l=0.84u
MM4_f10 VOUT2 VB1 VDD VDD pfet_03v3 w=0.5u l=0.84u
MM4_f11 VOUT2 VB1 VDD VDD pfet_03v3 w=0.5u l=0.84u
MM4_f12 VOUT2 VB1 VDD VDD pfet_03v3 w=0.5u l=0.84u
MM4_f13 VOUT2 VB1 VDD VDD pfet_03v3 w=0.5u l=0.84u
MM4_f14 VOUT2 VB1 VDD VDD pfet_03v3 w=0.5u l=0.84u
MM4_f15 VOUT2 VB1 VDD VDD pfet_03v3 w=0.5u l=0.84u
.ends C07_gf180_sW2_sL1.5
