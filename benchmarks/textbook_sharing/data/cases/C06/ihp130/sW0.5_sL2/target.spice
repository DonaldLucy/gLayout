.subckt C06_ihp130_sW0.5_sL2 VDD VSS VIN1 VOUT1 VB1 VB2 VB3
XM1 VOUT1 VB2 net10 VDD sg13_lv_pmos w=2u l=0.52u ng=4 m=1
XM2 net10 VB3 VDD VDD sg13_lv_pmos w=2u l=0.52u ng=4 m=1
XM3 net9 VIN1 VSS VSS sg13_lv_nmos w=1u l=0.52u ng=2 m=1
XM4 VOUT1 VB1 net9 VSS sg13_lv_nmos w=1u l=0.52u ng=2 m=1
.ends C06_ihp130_sW0.5_sL2
