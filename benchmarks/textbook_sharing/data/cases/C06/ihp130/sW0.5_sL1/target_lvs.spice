.subckt C06_ihp130_sW0.5_sL1 VDD VSS VIN1 VOUT1 VB1 VB2 VB3
XM1_f0 VOUT1 VB2 net10 VDD sg13_lv_pmos w=0.5u l=0.26u
XM1_f1 VOUT1 VB2 net10 VDD sg13_lv_pmos w=0.5u l=0.26u
XM1_f2 VOUT1 VB2 net10 VDD sg13_lv_pmos w=0.5u l=0.26u
XM1_f3 VOUT1 VB2 net10 VDD sg13_lv_pmos w=0.5u l=0.26u
XM2_f0 net10 VB3 VDD VDD sg13_lv_pmos w=0.5u l=0.26u
XM2_f1 net10 VB3 VDD VDD sg13_lv_pmos w=0.5u l=0.26u
XM2_f2 net10 VB3 VDD VDD sg13_lv_pmos w=0.5u l=0.26u
XM2_f3 net10 VB3 VDD VDD sg13_lv_pmos w=0.5u l=0.26u
XM3_f0 net9 VIN1 VSS VSS sg13_lv_nmos w=0.5u l=0.26u
XM3_f1 net9 VIN1 VSS VSS sg13_lv_nmos w=0.5u l=0.26u
XM4_f0 VOUT1 VB1 net9 VSS sg13_lv_nmos w=0.5u l=0.26u
XM4_f1 VOUT1 VB1 net9 VSS sg13_lv_nmos w=0.5u l=0.26u
.ends C06_ihp130_sW0.5_sL1
