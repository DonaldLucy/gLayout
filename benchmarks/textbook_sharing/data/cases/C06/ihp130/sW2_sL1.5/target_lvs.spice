.subckt C06_ihp130_sW2_sL1.5 VDD VSS VIN1 VOUT1 VB1 VB2 VB3
XM1_f0 VOUT1 VB2 net10 VDD sg13_lv_pmos w=0.5u l=0.39u
XM1_f1 VOUT1 VB2 net10 VDD sg13_lv_pmos w=0.5u l=0.39u
XM1_f2 VOUT1 VB2 net10 VDD sg13_lv_pmos w=0.5u l=0.39u
XM1_f3 VOUT1 VB2 net10 VDD sg13_lv_pmos w=0.5u l=0.39u
XM1_f4 VOUT1 VB2 net10 VDD sg13_lv_pmos w=0.5u l=0.39u
XM1_f5 VOUT1 VB2 net10 VDD sg13_lv_pmos w=0.5u l=0.39u
XM1_f6 VOUT1 VB2 net10 VDD sg13_lv_pmos w=0.5u l=0.39u
XM1_f7 VOUT1 VB2 net10 VDD sg13_lv_pmos w=0.5u l=0.39u
XM1_f8 VOUT1 VB2 net10 VDD sg13_lv_pmos w=0.5u l=0.39u
XM1_f9 VOUT1 VB2 net10 VDD sg13_lv_pmos w=0.5u l=0.39u
XM1_f10 VOUT1 VB2 net10 VDD sg13_lv_pmos w=0.5u l=0.39u
XM1_f11 VOUT1 VB2 net10 VDD sg13_lv_pmos w=0.5u l=0.39u
XM1_f12 VOUT1 VB2 net10 VDD sg13_lv_pmos w=0.5u l=0.39u
XM1_f13 VOUT1 VB2 net10 VDD sg13_lv_pmos w=0.5u l=0.39u
XM1_f14 VOUT1 VB2 net10 VDD sg13_lv_pmos w=0.5u l=0.39u
XM1_f15 VOUT1 VB2 net10 VDD sg13_lv_pmos w=0.5u l=0.39u
XM2_f0 net10 VB3 VDD VDD sg13_lv_pmos w=0.5u l=0.39u
XM2_f1 net10 VB3 VDD VDD sg13_lv_pmos w=0.5u l=0.39u
XM2_f2 net10 VB3 VDD VDD sg13_lv_pmos w=0.5u l=0.39u
XM2_f3 net10 VB3 VDD VDD sg13_lv_pmos w=0.5u l=0.39u
XM2_f4 net10 VB3 VDD VDD sg13_lv_pmos w=0.5u l=0.39u
XM2_f5 net10 VB3 VDD VDD sg13_lv_pmos w=0.5u l=0.39u
XM2_f6 net10 VB3 VDD VDD sg13_lv_pmos w=0.5u l=0.39u
XM2_f7 net10 VB3 VDD VDD sg13_lv_pmos w=0.5u l=0.39u
XM2_f8 net10 VB3 VDD VDD sg13_lv_pmos w=0.5u l=0.39u
XM2_f9 net10 VB3 VDD VDD sg13_lv_pmos w=0.5u l=0.39u
XM2_f10 net10 VB3 VDD VDD sg13_lv_pmos w=0.5u l=0.39u
XM2_f11 net10 VB3 VDD VDD sg13_lv_pmos w=0.5u l=0.39u
XM2_f12 net10 VB3 VDD VDD sg13_lv_pmos w=0.5u l=0.39u
XM2_f13 net10 VB3 VDD VDD sg13_lv_pmos w=0.5u l=0.39u
XM2_f14 net10 VB3 VDD VDD sg13_lv_pmos w=0.5u l=0.39u
XM2_f15 net10 VB3 VDD VDD sg13_lv_pmos w=0.5u l=0.39u
XM3_f0 net9 VIN1 VSS VSS sg13_lv_nmos w=0.5u l=0.39u
XM3_f1 net9 VIN1 VSS VSS sg13_lv_nmos w=0.5u l=0.39u
XM3_f2 net9 VIN1 VSS VSS sg13_lv_nmos w=0.5u l=0.39u
XM3_f3 net9 VIN1 VSS VSS sg13_lv_nmos w=0.5u l=0.39u
XM3_f4 net9 VIN1 VSS VSS sg13_lv_nmos w=0.5u l=0.39u
XM3_f5 net9 VIN1 VSS VSS sg13_lv_nmos w=0.5u l=0.39u
XM3_f6 net9 VIN1 VSS VSS sg13_lv_nmos w=0.5u l=0.39u
XM3_f7 net9 VIN1 VSS VSS sg13_lv_nmos w=0.5u l=0.39u
XM4_f0 VOUT1 VB1 net9 VSS sg13_lv_nmos w=0.5u l=0.39u
XM4_f1 VOUT1 VB1 net9 VSS sg13_lv_nmos w=0.5u l=0.39u
XM4_f2 VOUT1 VB1 net9 VSS sg13_lv_nmos w=0.5u l=0.39u
XM4_f3 VOUT1 VB1 net9 VSS sg13_lv_nmos w=0.5u l=0.39u
XM4_f4 VOUT1 VB1 net9 VSS sg13_lv_nmos w=0.5u l=0.39u
XM4_f5 VOUT1 VB1 net9 VSS sg13_lv_nmos w=0.5u l=0.39u
XM4_f6 VOUT1 VB1 net9 VSS sg13_lv_nmos w=0.5u l=0.39u
XM4_f7 VOUT1 VB1 net9 VSS sg13_lv_nmos w=0.5u l=0.39u
.ends C06_ihp130_sW2_sL1.5
