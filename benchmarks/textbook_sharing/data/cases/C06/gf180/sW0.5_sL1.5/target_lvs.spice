.subckt C06_gf180_sW0.5_sL1.5 VDD VSS VIN1 VOUT1 VB1 VB2 VB3
MM1_f0 VOUT1 VB2 net10 VDD pfet_03v3 w=0.5u l=0.84u
MM1_f1 VOUT1 VB2 net10 VDD pfet_03v3 w=0.5u l=0.84u
MM1_f2 VOUT1 VB2 net10 VDD pfet_03v3 w=0.5u l=0.84u
MM1_f3 VOUT1 VB2 net10 VDD pfet_03v3 w=0.5u l=0.84u
MM2_f0 net10 VB3 VDD VDD pfet_03v3 w=0.5u l=0.84u
MM2_f1 net10 VB3 VDD VDD pfet_03v3 w=0.5u l=0.84u
MM2_f2 net10 VB3 VDD VDD pfet_03v3 w=0.5u l=0.84u
MM2_f3 net10 VB3 VDD VDD pfet_03v3 w=0.5u l=0.84u
MM3_f0 net9 VIN1 VSS VSS nfet_03v3 w=0.5u l=0.84u
MM3_f1 net9 VIN1 VSS VSS nfet_03v3 w=0.5u l=0.84u
MM4_f0 VOUT1 VB1 net9 VSS nfet_03v3 w=0.5u l=0.84u
MM4_f1 VOUT1 VB1 net9 VSS nfet_03v3 w=0.5u l=0.84u
.ends C06_gf180_sW0.5_sL1.5
