.subckt C06_gf180_sW1_sL1 VDD VSS VIN1 VOUT1 VB1 VB2 VB3
MM1_f0 VOUT1 VB2 net10 VDD pfet_03v3 w=0.5u l=0.56u
MM1_f1 VOUT1 VB2 net10 VDD pfet_03v3 w=0.5u l=0.56u
MM1_f2 VOUT1 VB2 net10 VDD pfet_03v3 w=0.5u l=0.56u
MM1_f3 VOUT1 VB2 net10 VDD pfet_03v3 w=0.5u l=0.56u
MM1_f4 VOUT1 VB2 net10 VDD pfet_03v3 w=0.5u l=0.56u
MM1_f5 VOUT1 VB2 net10 VDD pfet_03v3 w=0.5u l=0.56u
MM1_f6 VOUT1 VB2 net10 VDD pfet_03v3 w=0.5u l=0.56u
MM1_f7 VOUT1 VB2 net10 VDD pfet_03v3 w=0.5u l=0.56u
MM2_f0 net10 VB3 VDD VDD pfet_03v3 w=0.5u l=0.56u
MM2_f1 net10 VB3 VDD VDD pfet_03v3 w=0.5u l=0.56u
MM2_f2 net10 VB3 VDD VDD pfet_03v3 w=0.5u l=0.56u
MM2_f3 net10 VB3 VDD VDD pfet_03v3 w=0.5u l=0.56u
MM2_f4 net10 VB3 VDD VDD pfet_03v3 w=0.5u l=0.56u
MM2_f5 net10 VB3 VDD VDD pfet_03v3 w=0.5u l=0.56u
MM2_f6 net10 VB3 VDD VDD pfet_03v3 w=0.5u l=0.56u
MM2_f7 net10 VB3 VDD VDD pfet_03v3 w=0.5u l=0.56u
MM3_f0 net9 VIN1 VSS VSS nfet_03v3 w=0.5u l=0.56u
MM3_f1 net9 VIN1 VSS VSS nfet_03v3 w=0.5u l=0.56u
MM3_f2 net9 VIN1 VSS VSS nfet_03v3 w=0.5u l=0.56u
MM3_f3 net9 VIN1 VSS VSS nfet_03v3 w=0.5u l=0.56u
MM4_f0 VOUT1 VB1 net9 VSS nfet_03v3 w=0.5u l=0.56u
MM4_f1 VOUT1 VB1 net9 VSS nfet_03v3 w=0.5u l=0.56u
MM4_f2 VOUT1 VB1 net9 VSS nfet_03v3 w=0.5u l=0.56u
MM4_f3 VOUT1 VB1 net9 VSS nfet_03v3 w=0.5u l=0.56u
.ends C06_gf180_sW1_sL1
