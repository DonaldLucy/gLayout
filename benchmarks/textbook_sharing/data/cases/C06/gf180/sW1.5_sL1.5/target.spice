.subckt C06_gf180_sW1.5_sL1.5 VDD VSS VIN1 VOUT1 VB1 VB2 VB3
MM1 VOUT1 VB2 net10 VDD pfet_03v3 w=6u l=0.84u nf=12 m=1
MM2 net10 VB3 VDD VDD pfet_03v3 w=6u l=0.84u nf=12 m=1
MM3 net9 VIN1 VSS VSS nfet_03v3 w=3u l=0.84u nf=6 m=1
MM4 VOUT1 VB1 net9 VSS nfet_03v3 w=3u l=0.84u nf=6 m=1
.ends C06_gf180_sW1.5_sL1.5
