X1 VDD VSS VIN1 VOUT1 VB1 VB2 VB3 C06_gf180_sW0.5_sL2
.include DUT_INCLUDE_PATH
VDD VDD 0 3.3
VSS VSS 0 0
VDDB VDDB 0 3.3
MB_VB1 VB1 VB1 VSS VSS nfet_03v3 w=1u l=1.12u
IB_VB1 VDDB VB1 8e-05
MB_VB2 VB2 VB2 VDDB VDDB pfet_03v3 w=2u l=1.12u
IB_VB2 VB2 VSS 8e-05
MB_VB3 VB3 VB3 VDDB VDDB pfet_03v3 w=2u l=1.12u
IB_VB3 VB3 VSS 2e-05
* DC servo (disclosed): V_in,dc follows V_out,dc through LFB (open at AC); AC drive through CIN
LFB VOUT1 VIN1 1e6
CIN VAC VIN1 1e6
VAC VAC 0 dc 0 ac 1
CL VOUT1 0 1e-13
.control
op
let vout0 = v(VOUT1)
let vin0 = v(VIN1)
let idd = -i(VDD)
print vout0 vin0 idd
ac dec 20 10 100G
let gdb = db(v(VOUT1))
meas ac gain_lf find gdb at=100
let g3 = gdb - gain_lf + 3
meas ac f3db when g3=0 cross=1
meas ac ugf when gdb=0 cross=1
quit
.endc
.end
