.subckt C06_sky130_sW2_sL1.5 VDD VSS VIN1 VOUT1 VB1 VB2 VB3
XM1 VOUT1 VB2 net10 VDD sky130_fd_pr__pfet_01v8 w=8 l=0.45 nf=16
XM2 net10 VB3 VDD VDD sky130_fd_pr__pfet_01v8 w=8 l=0.45 nf=16
XM3 net9 VIN1 VSS VSS sky130_fd_pr__nfet_01v8 w=4 l=0.45 nf=8
XM4 VOUT1 VB1 net9 VSS sky130_fd_pr__nfet_01v8 w=4 l=0.45 nf=8
.ends C06_sky130_sW2_sL1.5
