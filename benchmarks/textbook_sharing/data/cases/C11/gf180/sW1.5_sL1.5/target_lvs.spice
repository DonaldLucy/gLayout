.subckt C11_gf180_sW1.5_sL1.5 VDD VSS VIN1 VIN2 VOUT1 IB1
MM1_f0 IB1 IB1 VDD VDD pfet_03v3 w=0.5u l=0.84u
MM1_f1 IB1 IB1 VDD VDD pfet_03v3 w=0.5u l=0.84u
MM1_f2 IB1 IB1 VDD VDD pfet_03v3 w=0.5u l=0.84u
MM1_f3 IB1 IB1 VDD VDD pfet_03v3 w=0.5u l=0.84u
MM1_f4 IB1 IB1 VDD VDD pfet_03v3 w=0.5u l=0.84u
MM1_f5 IB1 IB1 VDD VDD pfet_03v3 w=0.5u l=0.84u
MM2_f0 net97 IB1 VDD VDD pfet_03v3 w=0.5u l=0.84u
MM2_f1 net97 IB1 VDD VDD pfet_03v3 w=0.5u l=0.84u
MM2_f2 net97 IB1 VDD VDD pfet_03v3 w=0.5u l=0.84u
MM2_f3 net97 IB1 VDD VDD pfet_03v3 w=0.5u l=0.84u
MM2_f4 net97 IB1 VDD VDD pfet_03v3 w=0.5u l=0.84u
MM2_f5 net97 IB1 VDD VDD pfet_03v3 w=0.5u l=0.84u
MM2_f6 net97 IB1 VDD VDD pfet_03v3 w=0.5u l=0.84u
MM2_f7 net97 IB1 VDD VDD pfet_03v3 w=0.5u l=0.84u
MM2_f8 net97 IB1 VDD VDD pfet_03v3 w=0.5u l=0.84u
MM2_f9 net97 IB1 VDD VDD pfet_03v3 w=0.5u l=0.84u
MM2_f10 net97 IB1 VDD VDD pfet_03v3 w=0.5u l=0.84u
MM2_f11 net97 IB1 VDD VDD pfet_03v3 w=0.5u l=0.84u
MM3_f0 net014 VIN1 net97 VDD pfet_03v3 w=0.5u l=0.84u
MM3_f1 net014 VIN1 net97 VDD pfet_03v3 w=0.5u l=0.84u
MM3_f2 net014 VIN1 net97 VDD pfet_03v3 w=0.5u l=0.84u
MM3_f3 net014 VIN1 net97 VDD pfet_03v3 w=0.5u l=0.84u
MM3_f4 net014 VIN1 net97 VDD pfet_03v3 w=0.5u l=0.84u
MM3_f5 net014 VIN1 net97 VDD pfet_03v3 w=0.5u l=0.84u
MM3_f6 net014 VIN1 net97 VDD pfet_03v3 w=0.5u l=0.84u
MM3_f7 net014 VIN1 net97 VDD pfet_03v3 w=0.5u l=0.84u
MM3_f8 net014 VIN1 net97 VDD pfet_03v3 w=0.5u l=0.84u
MM3_f9 net014 VIN1 net97 VDD pfet_03v3 w=0.5u l=0.84u
MM3_f10 net014 VIN1 net97 VDD pfet_03v3 w=0.5u l=0.84u
MM3_f11 net014 VIN1 net97 VDD pfet_03v3 w=0.5u l=0.84u
MM4_f0 net016 VIN2 net97 VDD pfet_03v3 w=0.5u l=0.84u
MM4_f1 net016 VIN2 net97 VDD pfet_03v3 w=0.5u l=0.84u
MM4_f2 net016 VIN2 net97 VDD pfet_03v3 w=0.5u l=0.84u
MM4_f3 net016 VIN2 net97 VDD pfet_03v3 w=0.5u l=0.84u
MM4_f4 net016 VIN2 net97 VDD pfet_03v3 w=0.5u l=0.84u
MM4_f5 net016 VIN2 net97 VDD pfet_03v3 w=0.5u l=0.84u
MM4_f6 net016 VIN2 net97 VDD pfet_03v3 w=0.5u l=0.84u
MM4_f7 net016 VIN2 net97 VDD pfet_03v3 w=0.5u l=0.84u
MM4_f8 net016 VIN2 net97 VDD pfet_03v3 w=0.5u l=0.84u
MM4_f9 net016 VIN2 net97 VDD pfet_03v3 w=0.5u l=0.84u
MM4_f10 net016 VIN2 net97 VDD pfet_03v3 w=0.5u l=0.84u
MM4_f11 net016 VIN2 net97 VDD pfet_03v3 w=0.5u l=0.84u
MM5_f0 net014 net014 VSS VSS nfet_03v3 w=0.5u l=0.84u
MM5_f1 net014 net014 VSS VSS nfet_03v3 w=0.5u l=0.84u
MM5_f2 net014 net014 VSS VSS nfet_03v3 w=0.5u l=0.84u
MM5_f3 net014 net014 VSS VSS nfet_03v3 w=0.5u l=0.84u
MM5_f4 net014 net014 VSS VSS nfet_03v3 w=0.5u l=0.84u
MM5_f5 net014 net014 VSS VSS nfet_03v3 w=0.5u l=0.84u
MM6_f0 net016 net014 VSS VSS nfet_03v3 w=0.5u l=0.84u
MM6_f1 net016 net014 VSS VSS nfet_03v3 w=0.5u l=0.84u
MM6_f2 net016 net014 VSS VSS nfet_03v3 w=0.5u l=0.84u
MM6_f3 net016 net014 VSS VSS nfet_03v3 w=0.5u l=0.84u
MM6_f4 net016 net014 VSS VSS nfet_03v3 w=0.5u l=0.84u
MM6_f5 net016 net014 VSS VSS nfet_03v3 w=0.5u l=0.84u
MM7_f0 VOUT1 IB1 VDD VDD pfet_03v3 w=0.5u l=0.84u
MM7_f1 VOUT1 IB1 VDD VDD pfet_03v3 w=0.5u l=0.84u
MM7_f2 VOUT1 IB1 VDD VDD pfet_03v3 w=0.5u l=0.84u
MM7_f3 VOUT1 IB1 VDD VDD pfet_03v3 w=0.5u l=0.84u
MM7_f4 VOUT1 IB1 VDD VDD pfet_03v3 w=0.5u l=0.84u
MM7_f5 VOUT1 IB1 VDD VDD pfet_03v3 w=0.5u l=0.84u
MM7_f6 VOUT1 IB1 VDD VDD pfet_03v3 w=0.5u l=0.84u
MM7_f7 VOUT1 IB1 VDD VDD pfet_03v3 w=0.5u l=0.84u
MM7_f8 VOUT1 IB1 VDD VDD pfet_03v3 w=0.5u l=0.84u
MM7_f9 VOUT1 IB1 VDD VDD pfet_03v3 w=0.5u l=0.84u
MM7_f10 VOUT1 IB1 VDD VDD pfet_03v3 w=0.5u l=0.84u
MM7_f11 VOUT1 IB1 VDD VDD pfet_03v3 w=0.5u l=0.84u
MM8_f0 VOUT1 net016 VSS VSS nfet_03v3 w=0.5u l=0.84u
MM8_f1 VOUT1 net016 VSS VSS nfet_03v3 w=0.5u l=0.84u
MM8_f2 VOUT1 net016 VSS VSS nfet_03v3 w=0.5u l=0.84u
MM8_f3 VOUT1 net016 VSS VSS nfet_03v3 w=0.5u l=0.84u
MM8_f4 VOUT1 net016 VSS VSS nfet_03v3 w=0.5u l=0.84u
MM8_f5 VOUT1 net016 VSS VSS nfet_03v3 w=0.5u l=0.84u
MM8_f6 VOUT1 net016 VSS VSS nfet_03v3 w=0.5u l=0.84u
MM8_f7 VOUT1 net016 VSS VSS nfet_03v3 w=0.5u l=0.84u
MM8_f8 VOUT1 net016 VSS VSS nfet_03v3 w=0.5u l=0.84u
MM8_f9 VOUT1 net016 VSS VSS nfet_03v3 w=0.5u l=0.84u
MM8_f10 VOUT1 net016 VSS VSS nfet_03v3 w=0.5u l=0.84u
MM8_f11 VOUT1 net016 VSS VSS nfet_03v3 w=0.5u l=0.84u
RR1 net016 net022 VSS ppolyf_u L=7.795u W=1u
CC1 net022 VOUT1 cap_mim_2f0_m4m5_noshield W=22.365u L=22.365u
.ends C11_gf180_sW1.5_sL1.5
