.subckt C11_gf180_sW0.5_sL2 VDD VSS VIN1 VIN2 VOUT1 IB1
MM1_f0 IB1 IB1 VDD VDD pfet_03v3 w=0.5u l=1.12u
MM1_f1 IB1 IB1 VDD VDD pfet_03v3 w=0.5u l=1.12u
MM2_f0 net97 IB1 VDD VDD pfet_03v3 w=0.5u l=1.12u
MM2_f1 net97 IB1 VDD VDD pfet_03v3 w=0.5u l=1.12u
MM2_f2 net97 IB1 VDD VDD pfet_03v3 w=0.5u l=1.12u
MM2_f3 net97 IB1 VDD VDD pfet_03v3 w=0.5u l=1.12u
MM3_f0 net014 VIN1 net97 VDD pfet_03v3 w=0.5u l=1.12u
MM3_f1 net014 VIN1 net97 VDD pfet_03v3 w=0.5u l=1.12u
MM3_f2 net014 VIN1 net97 VDD pfet_03v3 w=0.5u l=1.12u
MM3_f3 net014 VIN1 net97 VDD pfet_03v3 w=0.5u l=1.12u
MM4_f0 net016 VIN2 net97 VDD pfet_03v3 w=0.5u l=1.12u
MM4_f1 net016 VIN2 net97 VDD pfet_03v3 w=0.5u l=1.12u
MM4_f2 net016 VIN2 net97 VDD pfet_03v3 w=0.5u l=1.12u
MM4_f3 net016 VIN2 net97 VDD pfet_03v3 w=0.5u l=1.12u
MM5_f0 net014 net014 VSS VSS nfet_03v3 w=0.5u l=1.12u
MM5_f1 net014 net014 VSS VSS nfet_03v3 w=0.5u l=1.12u
MM6_f0 net016 net014 VSS VSS nfet_03v3 w=0.5u l=1.12u
MM6_f1 net016 net014 VSS VSS nfet_03v3 w=0.5u l=1.12u
MM7_f0 VOUT1 IB1 VDD VDD pfet_03v3 w=0.5u l=1.12u
MM7_f1 VOUT1 IB1 VDD VDD pfet_03v3 w=0.5u l=1.12u
MM7_f2 VOUT1 IB1 VDD VDD pfet_03v3 w=0.5u l=1.12u
MM7_f3 VOUT1 IB1 VDD VDD pfet_03v3 w=0.5u l=1.12u
MM8_f0 VOUT1 net016 VSS VSS nfet_03v3 w=0.5u l=1.12u
MM8_f1 VOUT1 net016 VSS VSS nfet_03v3 w=0.5u l=1.12u
MM8_f2 VOUT1 net016 VSS VSS nfet_03v3 w=0.5u l=1.12u
MM8_f3 VOUT1 net016 VSS VSS nfet_03v3 w=0.5u l=1.12u
RR1 net016 net022 VSS ppolyf_u L=7.795u W=1u
CC1 net022 VOUT1 cap_mim_2f0_m4m5_noshield W=22.365u L=22.365u
.ends C11_gf180_sW0.5_sL2
