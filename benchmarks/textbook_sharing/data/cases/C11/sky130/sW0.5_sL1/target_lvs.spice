.subckt C11_sky130_sW0.5_sL1 VDD VSS VIN1 VIN2 VOUT1 IB1
XM1_f0 IB1 IB1 VDD VDD sky130_fd_pr__pfet_01v8 w=0.5 l=0.3
XM1_f1 IB1 IB1 VDD VDD sky130_fd_pr__pfet_01v8 w=0.5 l=0.3
XM2_f0 net97 IB1 VDD VDD sky130_fd_pr__pfet_01v8 w=0.5 l=0.3
XM2_f1 net97 IB1 VDD VDD sky130_fd_pr__pfet_01v8 w=0.5 l=0.3
XM2_f2 net97 IB1 VDD VDD sky130_fd_pr__pfet_01v8 w=0.5 l=0.3
XM2_f3 net97 IB1 VDD VDD sky130_fd_pr__pfet_01v8 w=0.5 l=0.3
XM3_f0 net014 VIN1 net97 VDD sky130_fd_pr__pfet_01v8 w=0.5 l=0.3
XM3_f1 net014 VIN1 net97 VDD sky130_fd_pr__pfet_01v8 w=0.5 l=0.3
XM3_f2 net014 VIN1 net97 VDD sky130_fd_pr__pfet_01v8 w=0.5 l=0.3
XM3_f3 net014 VIN1 net97 VDD sky130_fd_pr__pfet_01v8 w=0.5 l=0.3
XM4_f0 net016 VIN2 net97 VDD sky130_fd_pr__pfet_01v8 w=0.5 l=0.3
XM4_f1 net016 VIN2 net97 VDD sky130_fd_pr__pfet_01v8 w=0.5 l=0.3
XM4_f2 net016 VIN2 net97 VDD sky130_fd_pr__pfet_01v8 w=0.5 l=0.3
XM4_f3 net016 VIN2 net97 VDD sky130_fd_pr__pfet_01v8 w=0.5 l=0.3
XM5_f0 net014 net014 VSS VSS sky130_fd_pr__nfet_01v8 w=0.5 l=0.3
XM5_f1 net014 net014 VSS VSS sky130_fd_pr__nfet_01v8 w=0.5 l=0.3
XM6_f0 net016 net014 VSS VSS sky130_fd_pr__nfet_01v8 w=0.5 l=0.3
XM6_f1 net016 net014 VSS VSS sky130_fd_pr__nfet_01v8 w=0.5 l=0.3
XM7_f0 VOUT1 IB1 VDD VDD sky130_fd_pr__pfet_01v8 w=0.5 l=0.3
XM7_f1 VOUT1 IB1 VDD VDD sky130_fd_pr__pfet_01v8 w=0.5 l=0.3
XM7_f2 VOUT1 IB1 VDD VDD sky130_fd_pr__pfet_01v8 w=0.5 l=0.3
XM7_f3 VOUT1 IB1 VDD VDD sky130_fd_pr__pfet_01v8 w=0.5 l=0.3
XM8_f0 VOUT1 net016 VSS VSS sky130_fd_pr__nfet_01v8 w=0.5 l=0.3
XM8_f1 VOUT1 net016 VSS VSS sky130_fd_pr__nfet_01v8 w=0.5 l=0.3
XM8_f2 VOUT1 net016 VSS VSS sky130_fd_pr__nfet_01v8 w=0.5 l=0.3
XM8_f3 VOUT1 net016 VSS VSS sky130_fd_pr__nfet_01v8 w=0.5 l=0.3
XRR1 net016 net022 VSS sky130_fd_pr__res_high_po_0p35 l=2.155 mult=1
XCC1 net022 VOUT1 sky130_fd_pr__cap_mim_m3_1 w=22.365 l=22.365
.ends C11_sky130_sW0.5_sL1
