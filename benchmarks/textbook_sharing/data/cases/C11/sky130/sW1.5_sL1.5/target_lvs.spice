.subckt C11_sky130_sW1.5_sL1.5 VDD VSS VIN1 VIN2 VOUT1 IB1
XM1_f0 IB1 IB1 VDD VDD sky130_fd_pr__pfet_01v8 w=0.5 l=0.45
XM1_f1 IB1 IB1 VDD VDD sky130_fd_pr__pfet_01v8 w=0.5 l=0.45
XM1_f2 IB1 IB1 VDD VDD sky130_fd_pr__pfet_01v8 w=0.5 l=0.45
XM1_f3 IB1 IB1 VDD VDD sky130_fd_pr__pfet_01v8 w=0.5 l=0.45
XM1_f4 IB1 IB1 VDD VDD sky130_fd_pr__pfet_01v8 w=0.5 l=0.45
XM1_f5 IB1 IB1 VDD VDD sky130_fd_pr__pfet_01v8 w=0.5 l=0.45
XM2_f0 net97 IB1 VDD VDD sky130_fd_pr__pfet_01v8 w=0.5 l=0.45
XM2_f1 net97 IB1 VDD VDD sky130_fd_pr__pfet_01v8 w=0.5 l=0.45
XM2_f2 net97 IB1 VDD VDD sky130_fd_pr__pfet_01v8 w=0.5 l=0.45
XM2_f3 net97 IB1 VDD VDD sky130_fd_pr__pfet_01v8 w=0.5 l=0.45
XM2_f4 net97 IB1 VDD VDD sky130_fd_pr__pfet_01v8 w=0.5 l=0.45
XM2_f5 net97 IB1 VDD VDD sky130_fd_pr__pfet_01v8 w=0.5 l=0.45
XM2_f6 net97 IB1 VDD VDD sky130_fd_pr__pfet_01v8 w=0.5 l=0.45
XM2_f7 net97 IB1 VDD VDD sky130_fd_pr__pfet_01v8 w=0.5 l=0.45
XM2_f8 net97 IB1 VDD VDD sky130_fd_pr__pfet_01v8 w=0.5 l=0.45
XM2_f9 net97 IB1 VDD VDD sky130_fd_pr__pfet_01v8 w=0.5 l=0.45
XM2_f10 net97 IB1 VDD VDD sky130_fd_pr__pfet_01v8 w=0.5 l=0.45
XM2_f11 net97 IB1 VDD VDD sky130_fd_pr__pfet_01v8 w=0.5 l=0.45
XM3_f0 net014 VIN1 net97 VDD sky130_fd_pr__pfet_01v8 w=0.5 l=0.45
XM3_f1 net014 VIN1 net97 VDD sky130_fd_pr__pfet_01v8 w=0.5 l=0.45
XM3_f2 net014 VIN1 net97 VDD sky130_fd_pr__pfet_01v8 w=0.5 l=0.45
XM3_f3 net014 VIN1 net97 VDD sky130_fd_pr__pfet_01v8 w=0.5 l=0.45
XM3_f4 net014 VIN1 net97 VDD sky130_fd_pr__pfet_01v8 w=0.5 l=0.45
XM3_f5 net014 VIN1 net97 VDD sky130_fd_pr__pfet_01v8 w=0.5 l=0.45
XM3_f6 net014 VIN1 net97 VDD sky130_fd_pr__pfet_01v8 w=0.5 l=0.45
XM3_f7 net014 VIN1 net97 VDD sky130_fd_pr__pfet_01v8 w=0.5 l=0.45
XM3_f8 net014 VIN1 net97 VDD sky130_fd_pr__pfet_01v8 w=0.5 l=0.45
XM3_f9 net014 VIN1 net97 VDD sky130_fd_pr__pfet_01v8 w=0.5 l=0.45
XM3_f10 net014 VIN1 net97 VDD sky130_fd_pr__pfet_01v8 w=0.5 l=0.45
XM3_f11 net014 VIN1 net97 VDD sky130_fd_pr__pfet_01v8 w=0.5 l=0.45
XM4_f0 net016 VIN2 net97 VDD sky130_fd_pr__pfet_01v8 w=0.5 l=0.45
XM4_f1 net016 VIN2 net97 VDD sky130_fd_pr__pfet_01v8 w=0.5 l=0.45
XM4_f2 net016 VIN2 net97 VDD sky130_fd_pr__pfet_01v8 w=0.5 l=0.45
XM4_f3 net016 VIN2 net97 VDD sky130_fd_pr__pfet_01v8 w=0.5 l=0.45
XM4_f4 net016 VIN2 net97 VDD sky130_fd_pr__pfet_01v8 w=0.5 l=0.45
XM4_f5 net016 VIN2 net97 VDD sky130_fd_pr__pfet_01v8 w=0.5 l=0.45
XM4_f6 net016 VIN2 net97 VDD sky130_fd_pr__pfet_01v8 w=0.5 l=0.45
XM4_f7 net016 VIN2 net97 VDD sky130_fd_pr__pfet_01v8 w=0.5 l=0.45
XM4_f8 net016 VIN2 net97 VDD sky130_fd_pr__pfet_01v8 w=0.5 l=0.45
XM4_f9 net016 VIN2 net97 VDD sky130_fd_pr__pfet_01v8 w=0.5 l=0.45
XM4_f10 net016 VIN2 net97 VDD sky130_fd_pr__pfet_01v8 w=0.5 l=0.45
XM4_f11 net016 VIN2 net97 VDD sky130_fd_pr__pfet_01v8 w=0.5 l=0.45
XM5_f0 net014 net014 VSS VSS sky130_fd_pr__nfet_01v8 w=0.5 l=0.45
XM5_f1 net014 net014 VSS VSS sky130_fd_pr__nfet_01v8 w=0.5 l=0.45
XM5_f2 net014 net014 VSS VSS sky130_fd_pr__nfet_01v8 w=0.5 l=0.45
XM5_f3 net014 net014 VSS VSS sky130_fd_pr__nfet_01v8 w=0.5 l=0.45
XM5_f4 net014 net014 VSS VSS sky130_fd_pr__nfet_01v8 w=0.5 l=0.45
XM5_f5 net014 net014 VSS VSS sky130_fd_pr__nfet_01v8 w=0.5 l=0.45
XM6_f0 net016 net014 VSS VSS sky130_fd_pr__nfet_01v8 w=0.5 l=0.45
XM6_f1 net016 net014 VSS VSS sky130_fd_pr__nfet_01v8 w=0.5 l=0.45
XM6_f2 net016 net014 VSS VSS sky130_fd_pr__nfet_01v8 w=0.5 l=0.45
XM6_f3 net016 net014 VSS VSS sky130_fd_pr__nfet_01v8 w=0.5 l=0.45
XM6_f4 net016 net014 VSS VSS sky130_fd_pr__nfet_01v8 w=0.5 l=0.45
XM6_f5 net016 net014 VSS VSS sky130_fd_pr__nfet_01v8 w=0.5 l=0.45
XM7_f0 VOUT1 IB1 VDD VDD sky130_fd_pr__pfet_01v8 w=0.5 l=0.45
XM7_f1 VOUT1 IB1 VDD VDD sky130_fd_pr__pfet_01v8 w=0.5 l=0.45
XM7_f2 VOUT1 IB1 VDD VDD sky130_fd_pr__pfet_01v8 w=0.5 l=0.45
XM7_f3 VOUT1 IB1 VDD VDD sky130_fd_pr__pfet_01v8 w=0.5 l=0.45
XM7_f4 VOUT1 IB1 VDD VDD sky130_fd_pr__pfet_01v8 w=0.5 l=0.45
XM7_f5 VOUT1 IB1 VDD VDD sky130_fd_pr__pfet_01v8 w=0.5 l=0.45
XM7_f6 VOUT1 IB1 VDD VDD sky130_fd_pr__pfet_01v8 w=0.5 l=0.45
XM7_f7 VOUT1 IB1 VDD VDD sky130_fd_pr__pfet_01v8 w=0.5 l=0.45
XM7_f8 VOUT1 IB1 VDD VDD sky130_fd_pr__pfet_01v8 w=0.5 l=0.45
XM7_f9 VOUT1 IB1 VDD VDD sky130_fd_pr__pfet_01v8 w=0.5 l=0.45
XM7_f10 VOUT1 IB1 VDD VDD sky130_fd_pr__pfet_01v8 w=0.5 l=0.45
XM7_f11 VOUT1 IB1 VDD VDD sky130_fd_pr__pfet_01v8 w=0.5 l=0.45
XM8_f0 VOUT1 net016 VSS VSS sky130_fd_pr__nfet_01v8 w=0.5 l=0.45
XM8_f1 VOUT1 net016 VSS VSS sky130_fd_pr__nfet_01v8 w=0.5 l=0.45
XM8_f2 VOUT1 net016 VSS VSS sky130_fd_pr__nfet_01v8 w=0.5 l=0.45
XM8_f3 VOUT1 net016 VSS VSS sky130_fd_pr__nfet_01v8 w=0.5 l=0.45
XM8_f4 VOUT1 net016 VSS VSS sky130_fd_pr__nfet_01v8 w=0.5 l=0.45
XM8_f5 VOUT1 net016 VSS VSS sky130_fd_pr__nfet_01v8 w=0.5 l=0.45
XM8_f6 VOUT1 net016 VSS VSS sky130_fd_pr__nfet_01v8 w=0.5 l=0.45
XM8_f7 VOUT1 net016 VSS VSS sky130_fd_pr__nfet_01v8 w=0.5 l=0.45
XM8_f8 VOUT1 net016 VSS VSS sky130_fd_pr__nfet_01v8 w=0.5 l=0.45
XM8_f9 VOUT1 net016 VSS VSS sky130_fd_pr__nfet_01v8 w=0.5 l=0.45
XM8_f10 VOUT1 net016 VSS VSS sky130_fd_pr__nfet_01v8 w=0.5 l=0.45
XM8_f11 VOUT1 net016 VSS VSS sky130_fd_pr__nfet_01v8 w=0.5 l=0.45
XRR1 net016 net022 VSS sky130_fd_pr__res_high_po_0p35 l=2.155 mult=1
XCC1 net022 VOUT1 sky130_fd_pr__cap_mim_m3_1 w=22.365 l=22.365
.ends C11_sky130_sW1.5_sL1.5
