.subckt C11_ihp130_sW0.5_sL1 VDD VSS VIN1 VIN2 VOUT1 IB1
XM1 IB1 IB1 VDD VDD sg13_lv_pmos w=1u l=0.26u ng=2 m=1
XM2 net97 IB1 VDD VDD sg13_lv_pmos w=2u l=0.26u ng=4 m=1
XM3 net014 VIN1 net97 VDD sg13_lv_pmos w=2u l=0.26u ng=4 m=1
XM4 net016 VIN2 net97 VDD sg13_lv_pmos w=2u l=0.26u ng=4 m=1
XM5 net014 net014 VSS VSS sg13_lv_nmos w=1u l=0.26u ng=2 m=1
XM6 net016 net014 VSS VSS sg13_lv_nmos w=1u l=0.26u ng=2 m=1
XM7 VOUT1 IB1 VDD VDD sg13_lv_pmos w=2u l=0.26u ng=4 m=1
XM8 VOUT1 net016 VSS VSS sg13_lv_nmos w=2u l=0.26u ng=4 m=1
XRR1 net016 net022 rppd w=1u l=11.38u m=1
XCC1 net022 VOUT1 cap_cmim w=25.82u l=25.82u
.ends C11_ihp130_sW0.5_sL1
