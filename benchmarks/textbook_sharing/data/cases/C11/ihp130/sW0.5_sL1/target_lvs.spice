.subckt C11_ihp130_sW0.5_sL1 VDD VSS VIN1 VIN2 VOUT1 IB1
XM1_f0 IB1 IB1 VDD VDD sg13_lv_pmos w=0.5u l=0.26u
XM1_f1 IB1 IB1 VDD VDD sg13_lv_pmos w=0.5u l=0.26u
XM2_f0 net97 IB1 VDD VDD sg13_lv_pmos w=0.5u l=0.26u
XM2_f1 net97 IB1 VDD VDD sg13_lv_pmos w=0.5u l=0.26u
XM2_f2 net97 IB1 VDD VDD sg13_lv_pmos w=0.5u l=0.26u
XM2_f3 net97 IB1 VDD VDD sg13_lv_pmos w=0.5u l=0.26u
XM3_f0 net014 VIN1 net97 VDD sg13_lv_pmos w=0.5u l=0.26u
XM3_f1 net014 VIN1 net97 VDD sg13_lv_pmos w=0.5u l=0.26u
XM3_f2 net014 VIN1 net97 VDD sg13_lv_pmos w=0.5u l=0.26u
XM3_f3 net014 VIN1 net97 VDD sg13_lv_pmos w=0.5u l=0.26u
XM4_f0 net016 VIN2 net97 VDD sg13_lv_pmos w=0.5u l=0.26u
XM4_f1 net016 VIN2 net97 VDD sg13_lv_pmos w=0.5u l=0.26u
XM4_f2 net016 VIN2 net97 VDD sg13_lv_pmos w=0.5u l=0.26u
XM4_f3 net016 VIN2 net97 VDD sg13_lv_pmos w=0.5u l=0.26u
XM5_f0 net014 net014 VSS VSS sg13_lv_nmos w=0.5u l=0.26u
XM5_f1 net014 net014 VSS VSS sg13_lv_nmos w=0.5u l=0.26u
XM6_f0 net016 net014 VSS VSS sg13_lv_nmos w=0.5u l=0.26u
XM6_f1 net016 net014 VSS VSS sg13_lv_nmos w=0.5u l=0.26u
XM7_f0 VOUT1 IB1 VDD VDD sg13_lv_pmos w=0.5u l=0.26u
XM7_f1 VOUT1 IB1 VDD VDD sg13_lv_pmos w=0.5u l=0.26u
XM7_f2 VOUT1 IB1 VDD VDD sg13_lv_pmos w=0.5u l=0.26u
XM7_f3 VOUT1 IB1 VDD VDD sg13_lv_pmos w=0.5u l=0.26u
XM8_f0 VOUT1 net016 VSS VSS sg13_lv_nmos w=0.5u l=0.26u
XM8_f1 VOUT1 net016 VSS VSS sg13_lv_nmos w=0.5u l=0.26u
XM8_f2 VOUT1 net016 VSS VSS sg13_lv_nmos w=0.5u l=0.26u
XM8_f3 VOUT1 net016 VSS VSS sg13_lv_nmos w=0.5u l=0.26u
XRR1 net016 net022 rppd w=1u l=11.38u m=1
XCC1 net022 VOUT1 cap_cmim w=25.82u l=25.82u
.ends C11_ihp130_sW0.5_sL1
