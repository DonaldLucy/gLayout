.subckt C11_ihp130_sW2_sL1.5 VDD VSS VIN1 VIN2 VOUT1 IB1
XM1_f0 IB1 IB1 VDD VDD sg13_lv_pmos w=0.5u l=0.39u
XM1_f1 IB1 IB1 VDD VDD sg13_lv_pmos w=0.5u l=0.39u
XM1_f2 IB1 IB1 VDD VDD sg13_lv_pmos w=0.5u l=0.39u
XM1_f3 IB1 IB1 VDD VDD sg13_lv_pmos w=0.5u l=0.39u
XM1_f4 IB1 IB1 VDD VDD sg13_lv_pmos w=0.5u l=0.39u
XM1_f5 IB1 IB1 VDD VDD sg13_lv_pmos w=0.5u l=0.39u
XM1_f6 IB1 IB1 VDD VDD sg13_lv_pmos w=0.5u l=0.39u
XM1_f7 IB1 IB1 VDD VDD sg13_lv_pmos w=0.5u l=0.39u
XM2_f0 net97 IB1 VDD VDD sg13_lv_pmos w=0.5u l=0.39u
XM2_f1 net97 IB1 VDD VDD sg13_lv_pmos w=0.5u l=0.39u
XM2_f2 net97 IB1 VDD VDD sg13_lv_pmos w=0.5u l=0.39u
XM2_f3 net97 IB1 VDD VDD sg13_lv_pmos w=0.5u l=0.39u
XM2_f4 net97 IB1 VDD VDD sg13_lv_pmos w=0.5u l=0.39u
XM2_f5 net97 IB1 VDD VDD sg13_lv_pmos w=0.5u l=0.39u
XM2_f6 net97 IB1 VDD VDD sg13_lv_pmos w=0.5u l=0.39u
XM2_f7 net97 IB1 VDD VDD sg13_lv_pmos w=0.5u l=0.39u
XM2_f8 net97 IB1 VDD VDD sg13_lv_pmos w=0.5u l=0.39u
XM2_f9 net97 IB1 VDD VDD sg13_lv_pmos w=0.5u l=0.39u
XM2_f10 net97 IB1 VDD VDD sg13_lv_pmos w=0.5u l=0.39u
XM2_f11 net97 IB1 VDD VDD sg13_lv_pmos w=0.5u l=0.39u
XM2_f12 net97 IB1 VDD VDD sg13_lv_pmos w=0.5u l=0.39u
XM2_f13 net97 IB1 VDD VDD sg13_lv_pmos w=0.5u l=0.39u
XM2_f14 net97 IB1 VDD VDD sg13_lv_pmos w=0.5u l=0.39u
XM2_f15 net97 IB1 VDD VDD sg13_lv_pmos w=0.5u l=0.39u
XM3_f0 net014 VIN1 net97 VDD sg13_lv_pmos w=0.5u l=0.39u
XM3_f1 net014 VIN1 net97 VDD sg13_lv_pmos w=0.5u l=0.39u
XM3_f2 net014 VIN1 net97 VDD sg13_lv_pmos w=0.5u l=0.39u
XM3_f3 net014 VIN1 net97 VDD sg13_lv_pmos w=0.5u l=0.39u
XM3_f4 net014 VIN1 net97 VDD sg13_lv_pmos w=0.5u l=0.39u
XM3_f5 net014 VIN1 net97 VDD sg13_lv_pmos w=0.5u l=0.39u
XM3_f6 net014 VIN1 net97 VDD sg13_lv_pmos w=0.5u l=0.39u
XM3_f7 net014 VIN1 net97 VDD sg13_lv_pmos w=0.5u l=0.39u
XM3_f8 net014 VIN1 net97 VDD sg13_lv_pmos w=0.5u l=0.39u
XM3_f9 net014 VIN1 net97 VDD sg13_lv_pmos w=0.5u l=0.39u
XM3_f10 net014 VIN1 net97 VDD sg13_lv_pmos w=0.5u l=0.39u
XM3_f11 net014 VIN1 net97 VDD sg13_lv_pmos w=0.5u l=0.39u
XM3_f12 net014 VIN1 net97 VDD sg13_lv_pmos w=0.5u l=0.39u
XM3_f13 net014 VIN1 net97 VDD sg13_lv_pmos w=0.5u l=0.39u
XM3_f14 net014 VIN1 net97 VDD sg13_lv_pmos w=0.5u l=0.39u
XM3_f15 net014 VIN1 net97 VDD sg13_lv_pmos w=0.5u l=0.39u
XM4_f0 net016 VIN2 net97 VDD sg13_lv_pmos w=0.5u l=0.39u
XM4_f1 net016 VIN2 net97 VDD sg13_lv_pmos w=0.5u l=0.39u
XM4_f2 net016 VIN2 net97 VDD sg13_lv_pmos w=0.5u l=0.39u
XM4_f3 net016 VIN2 net97 VDD sg13_lv_pmos w=0.5u l=0.39u
XM4_f4 net016 VIN2 net97 VDD sg13_lv_pmos w=0.5u l=0.39u
XM4_f5 net016 VIN2 net97 VDD sg13_lv_pmos w=0.5u l=0.39u
XM4_f6 net016 VIN2 net97 VDD sg13_lv_pmos w=0.5u l=0.39u
XM4_f7 net016 VIN2 net97 VDD sg13_lv_pmos w=0.5u l=0.39u
XM4_f8 net016 VIN2 net97 VDD sg13_lv_pmos w=0.5u l=0.39u
XM4_f9 net016 VIN2 net97 VDD sg13_lv_pmos w=0.5u l=0.39u
XM4_f10 net016 VIN2 net97 VDD sg13_lv_pmos w=0.5u l=0.39u
XM4_f11 net016 VIN2 net97 VDD sg13_lv_pmos w=0.5u l=0.39u
XM4_f12 net016 VIN2 net97 VDD sg13_lv_pmos w=0.5u l=0.39u
XM4_f13 net016 VIN2 net97 VDD sg13_lv_pmos w=0.5u l=0.39u
XM4_f14 net016 VIN2 net97 VDD sg13_lv_pmos w=0.5u l=0.39u
XM4_f15 net016 VIN2 net97 VDD sg13_lv_pmos w=0.5u l=0.39u
XM5_f0 net014 net014 VSS VSS sg13_lv_nmos w=0.5u l=0.39u
XM5_f1 net014 net014 VSS VSS sg13_lv_nmos w=0.5u l=0.39u
XM5_f2 net014 net014 VSS VSS sg13_lv_nmos w=0.5u l=0.39u
XM5_f3 net014 net014 VSS VSS sg13_lv_nmos w=0.5u l=0.39u
XM5_f4 net014 net014 VSS VSS sg13_lv_nmos w=0.5u l=0.39u
XM5_f5 net014 net014 VSS VSS sg13_lv_nmos w=0.5u l=0.39u
XM5_f6 net014 net014 VSS VSS sg13_lv_nmos w=0.5u l=0.39u
XM5_f7 net014 net014 VSS VSS sg13_lv_nmos w=0.5u l=0.39u
XM6_f0 net016 net014 VSS VSS sg13_lv_nmos w=0.5u l=0.39u
XM6_f1 net016 net014 VSS VSS sg13_lv_nmos w=0.5u l=0.39u
XM6_f2 net016 net014 VSS VSS sg13_lv_nmos w=0.5u l=0.39u
XM6_f3 net016 net014 VSS VSS sg13_lv_nmos w=0.5u l=0.39u
XM6_f4 net016 net014 VSS VSS sg13_lv_nmos w=0.5u l=0.39u
XM6_f5 net016 net014 VSS VSS sg13_lv_nmos w=0.5u l=0.39u
XM6_f6 net016 net014 VSS VSS sg13_lv_nmos w=0.5u l=0.39u
XM6_f7 net016 net014 VSS VSS sg13_lv_nmos w=0.5u l=0.39u
XM7_f0 VOUT1 IB1 VDD VDD sg13_lv_pmos w=0.5u l=0.39u
XM7_f1 VOUT1 IB1 VDD VDD sg13_lv_pmos w=0.5u l=0.39u
XM7_f2 VOUT1 IB1 VDD VDD sg13_lv_pmos w=0.5u l=0.39u
XM7_f3 VOUT1 IB1 VDD VDD sg13_lv_pmos w=0.5u l=0.39u
XM7_f4 VOUT1 IB1 VDD VDD sg13_lv_pmos w=0.5u l=0.39u
XM7_f5 VOUT1 IB1 VDD VDD sg13_lv_pmos w=0.5u l=0.39u
XM7_f6 VOUT1 IB1 VDD VDD sg13_lv_pmos w=0.5u l=0.39u
XM7_f7 VOUT1 IB1 VDD VDD sg13_lv_pmos w=0.5u l=0.39u
XM7_f8 VOUT1 IB1 VDD VDD sg13_lv_pmos w=0.5u l=0.39u
XM7_f9 VOUT1 IB1 VDD VDD sg13_lv_pmos w=0.5u l=0.39u
XM7_f10 VOUT1 IB1 VDD VDD sg13_lv_pmos w=0.5u l=0.39u
XM7_f11 VOUT1 IB1 VDD VDD sg13_lv_pmos w=0.5u l=0.39u
XM7_f12 VOUT1 IB1 VDD VDD sg13_lv_pmos w=0.5u l=0.39u
XM7_f13 VOUT1 IB1 VDD VDD sg13_lv_pmos w=0.5u l=0.39u
XM7_f14 VOUT1 IB1 VDD VDD sg13_lv_pmos w=0.5u l=0.39u
XM7_f15 VOUT1 IB1 VDD VDD sg13_lv_pmos w=0.5u l=0.39u
XM8_f0 VOUT1 net016 VSS VSS sg13_lv_nmos w=0.5u l=0.39u
XM8_f1 VOUT1 net016 VSS VSS sg13_lv_nmos w=0.5u l=0.39u
XM8_f2 VOUT1 net016 VSS VSS sg13_lv_nmos w=0.5u l=0.39u
XM8_f3 VOUT1 net016 VSS VSS sg13_lv_nmos w=0.5u l=0.39u
XM8_f4 VOUT1 net016 VSS VSS sg13_lv_nmos w=0.5u l=0.39u
XM8_f5 VOUT1 net016 VSS VSS sg13_lv_nmos w=0.5u l=0.39u
XM8_f6 VOUT1 net016 VSS VSS sg13_lv_nmos w=0.5u l=0.39u
XM8_f7 VOUT1 net016 VSS VSS sg13_lv_nmos w=0.5u l=0.39u
XM8_f8 VOUT1 net016 VSS VSS sg13_lv_nmos w=0.5u l=0.39u
XM8_f9 VOUT1 net016 VSS VSS sg13_lv_nmos w=0.5u l=0.39u
XM8_f10 VOUT1 net016 VSS VSS sg13_lv_nmos w=0.5u l=0.39u
XM8_f11 VOUT1 net016 VSS VSS sg13_lv_nmos w=0.5u l=0.39u
XM8_f12 VOUT1 net016 VSS VSS sg13_lv_nmos w=0.5u l=0.39u
XM8_f13 VOUT1 net016 VSS VSS sg13_lv_nmos w=0.5u l=0.39u
XM8_f14 VOUT1 net016 VSS VSS sg13_lv_nmos w=0.5u l=0.39u
XM8_f15 VOUT1 net016 VSS VSS sg13_lv_nmos w=0.5u l=0.39u
XRR1 net016 net022 rppd w=1u l=11.38u m=1
XCC1 net022 VOUT1 cap_cmim w=25.82u l=25.82u
.ends C11_ihp130_sW2_sL1.5
