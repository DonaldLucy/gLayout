.subckt C15_gf180_sW1.5_sL1.5 VDD VSS VIN1 VOUT1
MM1 VOUT1 VIN1 VSS VSS nfet_03v3 w=3u l=0.84u nf=6 m=1
XRR1 VDD VOUT1 VSS ppolyf_u r_width=1u r_length=60u
.ends C15_gf180_sW1.5_sL1.5
