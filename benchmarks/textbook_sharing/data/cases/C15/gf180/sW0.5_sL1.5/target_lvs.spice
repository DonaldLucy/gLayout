.subckt C15_gf180_sW0.5_sL1.5 VDD VSS VIN1 VOUT1
MM1_f0 VOUT1 VIN1 VSS VSS nfet_03v3 w=0.5u l=0.84u
MM1_f1 VOUT1 VIN1 VSS VSS nfet_03v3 w=0.5u l=0.84u
RR1 VDD VOUT1 VSS ppolyf_u L=60u W=1u
.ends C15_gf180_sW0.5_sL1.5
