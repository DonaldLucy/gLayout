X1 VDD VSS VIN1 VOUT1 VB1 C05_sky130_sW0.5_sL1
.include DUT_INCLUDE_PATH
VDD VDD 0 1.8
VSS VSS 0 0
VDDB VDDB 0 1.8
XB_VB1 VB1 VB1 VSS VSS sky130_fd_pr__nfet_01v8 w=1 l=0.3
IB_VB1 VDDB VB1 2e-05
VIN1 VIN1 0 dc 1.17 ac 1
RL VOUT1 0 20000
CL VOUT1 0 1e-12
.control
op
let vout0 = v(VOUT1)
let idd = -i(VDD)
print vout0 idd
dc VIN1 0 1.8 0.0045
let gain_dc = deriv(v(VOUT1))
meas dc gain_at_nom find gain_dc at=1.17
meas dc vout_at_nom find v(VOUT1) at=1.17
let okg = gain_dc - 0.5
meas dc vin_lo find v(VIN1) when okg=0 cross=1
meas dc vin_hi find v(VIN1) when okg=0 cross=last
ac dec 20 1k 10G
let gdb = db(v(VOUT1))
meas ac gain_lf find gdb at=1k
let g3 = gdb - gain_lf + 3
meas ac f3db when g3=0 cross=1
quit
.endc
.end
