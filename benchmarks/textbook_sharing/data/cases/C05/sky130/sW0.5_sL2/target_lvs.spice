.subckt C05_sky130_sW0.5_sL2 VDD VSS VIN1 VOUT1 VB1
XM1_f0 VOUT1 VB1 VSS VSS sky130_fd_pr__nfet_01v8 w=0.5 l=0.6
XM1_f1 VOUT1 VB1 VSS VSS sky130_fd_pr__nfet_01v8 w=0.5 l=0.6
XM2_f0 VDD VIN1 VOUT1 VSS sky130_fd_pr__nfet_01v8 w=0.5 l=0.6
XM2_f1 VDD VIN1 VOUT1 VSS sky130_fd_pr__nfet_01v8 w=0.5 l=0.6
XM2_f2 VDD VIN1 VOUT1 VSS sky130_fd_pr__nfet_01v8 w=0.5 l=0.6
XM2_f3 VDD VIN1 VOUT1 VSS sky130_fd_pr__nfet_01v8 w=0.5 l=0.6
.ends C05_sky130_sW0.5_sL2
