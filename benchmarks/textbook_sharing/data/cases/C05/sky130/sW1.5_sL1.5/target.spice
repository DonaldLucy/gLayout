.subckt C05_sky130_sW1.5_sL1.5 VDD VSS VIN1 VOUT1 VB1
XM1 VOUT1 VB1 VSS VSS sky130_fd_pr__nfet_01v8 w=3 l=0.45 nf=6
XM2 VDD VIN1 VOUT1 VSS sky130_fd_pr__nfet_01v8 w=6 l=0.45 nf=12
.ends C05_sky130_sW1.5_sL1.5
