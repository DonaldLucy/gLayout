.subckt C05_ihp130_sW1.5_sL2 VDD VSS VIN1 VOUT1 VB1
XM1 VOUT1 VB1 VSS VSS sg13_lv_nmos w=3u l=0.52u ng=6 m=1
XM2 VDD VIN1 VOUT1 VSS sg13_lv_nmos w=6u l=0.52u ng=12 m=1
.ends C05_ihp130_sW1.5_sL2
