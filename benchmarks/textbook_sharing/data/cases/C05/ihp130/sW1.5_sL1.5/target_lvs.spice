.subckt C05_ihp130_sW1.5_sL1.5 VDD VSS VIN1 VOUT1 VB1
XM1_f0 VOUT1 VB1 VSS VSS sg13_lv_nmos w=0.5u l=0.39u
XM1_f1 VOUT1 VB1 VSS VSS sg13_lv_nmos w=0.5u l=0.39u
XM1_f2 VOUT1 VB1 VSS VSS sg13_lv_nmos w=0.5u l=0.39u
XM1_f3 VOUT1 VB1 VSS VSS sg13_lv_nmos w=0.5u l=0.39u
XM1_f4 VOUT1 VB1 VSS VSS sg13_lv_nmos w=0.5u l=0.39u
XM1_f5 VOUT1 VB1 VSS VSS sg13_lv_nmos w=0.5u l=0.39u
XM2_f0 VDD VIN1 VOUT1 VSS sg13_lv_nmos w=0.5u l=0.39u
XM2_f1 VDD VIN1 VOUT1 VSS sg13_lv_nmos w=0.5u l=0.39u
XM2_f2 VDD VIN1 VOUT1 VSS sg13_lv_nmos w=0.5u l=0.39u
XM2_f3 VDD VIN1 VOUT1 VSS sg13_lv_nmos w=0.5u l=0.39u
XM2_f4 VDD VIN1 VOUT1 VSS sg13_lv_nmos w=0.5u l=0.39u
XM2_f5 VDD VIN1 VOUT1 VSS sg13_lv_nmos w=0.5u l=0.39u
XM2_f6 VDD VIN1 VOUT1 VSS sg13_lv_nmos w=0.5u l=0.39u
XM2_f7 VDD VIN1 VOUT1 VSS sg13_lv_nmos w=0.5u l=0.39u
XM2_f8 VDD VIN1 VOUT1 VSS sg13_lv_nmos w=0.5u l=0.39u
XM2_f9 VDD VIN1 VOUT1 VSS sg13_lv_nmos w=0.5u l=0.39u
XM2_f10 VDD VIN1 VOUT1 VSS sg13_lv_nmos w=0.5u l=0.39u
XM2_f11 VDD VIN1 VOUT1 VSS sg13_lv_nmos w=0.5u l=0.39u
.ends C05_ihp130_sW1.5_sL1.5
