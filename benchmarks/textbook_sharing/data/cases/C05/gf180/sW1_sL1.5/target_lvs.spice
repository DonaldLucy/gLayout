.subckt C05_gf180_sW1_sL1.5 VDD VSS VIN1 VOUT1 VB1
MM1_f0 VOUT1 VB1 VSS VSS nfet_03v3 w=0.5u l=0.84u
MM1_f1 VOUT1 VB1 VSS VSS nfet_03v3 w=0.5u l=0.84u
MM1_f2 VOUT1 VB1 VSS VSS nfet_03v3 w=0.5u l=0.84u
MM1_f3 VOUT1 VB1 VSS VSS nfet_03v3 w=0.5u l=0.84u
MM2_f0 VDD VIN1 VOUT1 VSS nfet_03v3 w=0.5u l=0.84u
MM2_f1 VDD VIN1 VOUT1 VSS nfet_03v3 w=0.5u l=0.84u
MM2_f2 VDD VIN1 VOUT1 VSS nfet_03v3 w=0.5u l=0.84u
MM2_f3 VDD VIN1 VOUT1 VSS nfet_03v3 w=0.5u l=0.84u
MM2_f4 VDD VIN1 VOUT1 VSS nfet_03v3 w=0.5u l=0.84u
MM2_f5 VDD VIN1 VOUT1 VSS nfet_03v3 w=0.5u l=0.84u
MM2_f6 VDD VIN1 VOUT1 VSS nfet_03v3 w=0.5u l=0.84u
MM2_f7 VDD VIN1 VOUT1 VSS nfet_03v3 w=0.5u l=0.84u
.ends C05_gf180_sW1_sL1.5
