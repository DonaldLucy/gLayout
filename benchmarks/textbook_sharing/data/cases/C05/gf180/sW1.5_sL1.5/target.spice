.subckt C05_gf180_sW1.5_sL1.5 VDD VSS VIN1 VOUT1 VB1
MM1 VOUT1 VB1 VSS VSS nfet_03v3 w=3u l=0.84u nf=6 m=1
MM2 VDD VIN1 VOUT1 VSS nfet_03v3 w=6u l=0.84u nf=12 m=1
.ends C05_gf180_sW1.5_sL1.5
