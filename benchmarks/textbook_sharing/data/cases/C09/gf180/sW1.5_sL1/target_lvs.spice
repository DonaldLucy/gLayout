.subckt C09_gf180_sW1.5_sL1 VDD VSS VIN1 VIN2 VOUT1 VB1 IB1
MM1_f0 net018 VIN1 IB1 VSS nfet_03v3 w=0.5u l=0.56u
MM1_f1 net018 VIN1 IB1 VSS nfet_03v3 w=0.5u l=0.56u
MM1_f2 net018 VIN1 IB1 VSS nfet_03v3 w=0.5u l=0.56u
MM1_f3 net018 VIN1 IB1 VSS nfet_03v3 w=0.5u l=0.56u
MM1_f4 net018 VIN1 IB1 VSS nfet_03v3 w=0.5u l=0.56u
MM1_f5 net018 VIN1 IB1 VSS nfet_03v3 w=0.5u l=0.56u
MM1_f6 net018 VIN1 IB1 VSS nfet_03v3 w=0.5u l=0.56u
MM1_f7 net018 VIN1 IB1 VSS nfet_03v3 w=0.5u l=0.56u
MM1_f8 net018 VIN1 IB1 VSS nfet_03v3 w=0.5u l=0.56u
MM1_f9 net018 VIN1 IB1 VSS nfet_03v3 w=0.5u l=0.56u
MM1_f10 net018 VIN1 IB1 VSS nfet_03v3 w=0.5u l=0.56u
MM1_f11 net018 VIN1 IB1 VSS nfet_03v3 w=0.5u l=0.56u
MM2_f0 net016 VIN2 IB1 VSS nfet_03v3 w=0.5u l=0.56u
MM2_f1 net016 VIN2 IB1 VSS nfet_03v3 w=0.5u l=0.56u
MM2_f2 net016 VIN2 IB1 VSS nfet_03v3 w=0.5u l=0.56u
MM2_f3 net016 VIN2 IB1 VSS nfet_03v3 w=0.5u l=0.56u
MM2_f4 net016 VIN2 IB1 VSS nfet_03v3 w=0.5u l=0.56u
MM2_f5 net016 VIN2 IB1 VSS nfet_03v3 w=0.5u l=0.56u
MM2_f6 net016 VIN2 IB1 VSS nfet_03v3 w=0.5u l=0.56u
MM2_f7 net016 VIN2 IB1 VSS nfet_03v3 w=0.5u l=0.56u
MM2_f8 net016 VIN2 IB1 VSS nfet_03v3 w=0.5u l=0.56u
MM2_f9 net016 VIN2 IB1 VSS nfet_03v3 w=0.5u l=0.56u
MM2_f10 net016 VIN2 IB1 VSS nfet_03v3 w=0.5u l=0.56u
MM2_f11 net016 VIN2 IB1 VSS nfet_03v3 w=0.5u l=0.56u
MM3_f0 net04 VB1 net018 VSS nfet_03v3 w=0.5u l=0.56u
MM3_f1 net04 VB1 net018 VSS nfet_03v3 w=0.5u l=0.56u
MM3_f2 net04 VB1 net018 VSS nfet_03v3 w=0.5u l=0.56u
MM3_f3 net04 VB1 net018 VSS nfet_03v3 w=0.5u l=0.56u
MM3_f4 net04 VB1 net018 VSS nfet_03v3 w=0.5u l=0.56u
MM3_f5 net04 VB1 net018 VSS nfet_03v3 w=0.5u l=0.56u
MM3_f6 net04 VB1 net018 VSS nfet_03v3 w=0.5u l=0.56u
MM3_f7 net04 VB1 net018 VSS nfet_03v3 w=0.5u l=0.56u
MM3_f8 net04 VB1 net018 VSS nfet_03v3 w=0.5u l=0.56u
MM3_f9 net04 VB1 net018 VSS nfet_03v3 w=0.5u l=0.56u
MM3_f10 net04 VB1 net018 VSS nfet_03v3 w=0.5u l=0.56u
MM3_f11 net04 VB1 net018 VSS nfet_03v3 w=0.5u l=0.56u
MM4_f0 VOUT1 VB1 net016 VSS nfet_03v3 w=0.5u l=0.56u
MM4_f1 VOUT1 VB1 net016 VSS nfet_03v3 w=0.5u l=0.56u
MM4_f2 VOUT1 VB1 net016 VSS nfet_03v3 w=0.5u l=0.56u
MM4_f3 VOUT1 VB1 net016 VSS nfet_03v3 w=0.5u l=0.56u
MM4_f4 VOUT1 VB1 net016 VSS nfet_03v3 w=0.5u l=0.56u
MM4_f5 VOUT1 VB1 net016 VSS nfet_03v3 w=0.5u l=0.56u
MM4_f6 VOUT1 VB1 net016 VSS nfet_03v3 w=0.5u l=0.56u
MM4_f7 VOUT1 VB1 net016 VSS nfet_03v3 w=0.5u l=0.56u
MM4_f8 VOUT1 VB1 net016 VSS nfet_03v3 w=0.5u l=0.56u
MM4_f9 VOUT1 VB1 net016 VSS nfet_03v3 w=0.5u l=0.56u
MM4_f10 VOUT1 VB1 net016 VSS nfet_03v3 w=0.5u l=0.56u
MM4_f11 VOUT1 VB1 net016 VSS nfet_03v3 w=0.5u l=0.56u
MM5_f0 net04 net04 net019 VDD pfet_03v3 w=0.5u l=0.56u
MM5_f1 net04 net04 net019 VDD pfet_03v3 w=0.5u l=0.56u
MM5_f2 net04 net04 net019 VDD pfet_03v3 w=0.5u l=0.56u
MM5_f3 net04 net04 net019 VDD pfet_03v3 w=0.5u l=0.56u
MM5_f4 net04 net04 net019 VDD pfet_03v3 w=0.5u l=0.56u
MM5_f5 net04 net04 net019 VDD pfet_03v3 w=0.5u l=0.56u
MM5_f6 net04 net04 net019 VDD pfet_03v3 w=0.5u l=0.56u
MM5_f7 net04 net04 net019 VDD pfet_03v3 w=0.5u l=0.56u
MM5_f8 net04 net04 net019 VDD pfet_03v3 w=0.5u l=0.56u
MM5_f9 net04 net04 net019 VDD pfet_03v3 w=0.5u l=0.56u
MM5_f10 net04 net04 net019 VDD pfet_03v3 w=0.5u l=0.56u
MM5_f11 net04 net04 net019 VDD pfet_03v3 w=0.5u l=0.56u
MM6_f0 VOUT1 net04 net017 VDD pfet_03v3 w=0.5u l=0.56u
MM6_f1 VOUT1 net04 net017 VDD pfet_03v3 w=0.5u l=0.56u
MM6_f2 VOUT1 net04 net017 VDD pfet_03v3 w=0.5u l=0.56u
MM6_f3 VOUT1 net04 net017 VDD pfet_03v3 w=0.5u l=0.56u
MM6_f4 VOUT1 net04 net017 VDD pfet_03v3 w=0.5u l=0.56u
MM6_f5 VOUT1 net04 net017 VDD pfet_03v3 w=0.5u l=0.56u
MM6_f6 VOUT1 net04 net017 VDD pfet_03v3 w=0.5u l=0.56u
MM6_f7 VOUT1 net04 net017 VDD pfet_03v3 w=0.5u l=0.56u
MM6_f8 VOUT1 net04 net017 VDD pfet_03v3 w=0.5u l=0.56u
MM6_f9 VOUT1 net04 net017 VDD pfet_03v3 w=0.5u l=0.56u
MM6_f10 VOUT1 net04 net017 VDD pfet_03v3 w=0.5u l=0.56u
MM6_f11 VOUT1 net04 net017 VDD pfet_03v3 w=0.5u l=0.56u
MM7_f0 net019 net019 VDD VDD pfet_03v3 w=0.5u l=0.56u
MM7_f1 net019 net019 VDD VDD pfet_03v3 w=0.5u l=0.56u
MM7_f2 net019 net019 VDD VDD pfet_03v3 w=0.5u l=0.56u
MM7_f3 net019 net019 VDD VDD pfet_03v3 w=0.5u l=0.56u
MM7_f4 net019 net019 VDD VDD pfet_03v3 w=0.5u l=0.56u
MM7_f5 net019 net019 VDD VDD pfet_03v3 w=0.5u l=0.56u
MM7_f6 net019 net019 VDD VDD pfet_03v3 w=0.5u l=0.56u
MM7_f7 net019 net019 VDD VDD pfet_03v3 w=0.5u l=0.56u
MM7_f8 net019 net019 VDD VDD pfet_03v3 w=0.5u l=0.56u
MM7_f9 net019 net019 VDD VDD pfet_03v3 w=0.5u l=0.56u
MM7_f10 net019 net019 VDD VDD pfet_03v3 w=0.5u l=0.56u
MM7_f11 net019 net019 VDD VDD pfet_03v3 w=0.5u l=0.56u
MM8_f0 net017 net019 VDD VDD pfet_03v3 w=0.5u l=0.56u
MM8_f1 net017 net019 VDD VDD pfet_03v3 w=0.5u l=0.56u
MM8_f2 net017 net019 VDD VDD pfet_03v3 w=0.5u l=0.56u
MM8_f3 net017 net019 VDD VDD pfet_03v3 w=0.5u l=0.56u
MM8_f4 net017 net019 VDD VDD pfet_03v3 w=0.5u l=0.56u
MM8_f5 net017 net019 VDD VDD pfet_03v3 w=0.5u l=0.56u
MM8_f6 net017 net019 VDD VDD pfet_03v3 w=0.5u l=0.56u
MM8_f7 net017 net019 VDD VDD pfet_03v3 w=0.5u l=0.56u
MM8_f8 net017 net019 VDD VDD pfet_03v3 w=0.5u l=0.56u
MM8_f9 net017 net019 VDD VDD pfet_03v3 w=0.5u l=0.56u
MM8_f10 net017 net019 VDD VDD pfet_03v3 w=0.5u l=0.56u
MM8_f11 net017 net019 VDD VDD pfet_03v3 w=0.5u l=0.56u
.ends C09_gf180_sW1.5_sL1
