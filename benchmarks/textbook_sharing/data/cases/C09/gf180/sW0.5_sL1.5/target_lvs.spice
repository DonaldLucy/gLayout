.subckt C09_gf180_sW0.5_sL1.5 VDD VSS VIN1 VIN2 VOUT1 VB1 IB1
MM1_f0 net018 VIN1 IB1 VSS nfet_03v3 w=0.5u l=0.84u
MM1_f1 net018 VIN1 IB1 VSS nfet_03v3 w=0.5u l=0.84u
MM1_f2 net018 VIN1 IB1 VSS nfet_03v3 w=0.5u l=0.84u
MM1_f3 net018 VIN1 IB1 VSS nfet_03v3 w=0.5u l=0.84u
MM2_f0 net016 VIN2 IB1 VSS nfet_03v3 w=0.5u l=0.84u
MM2_f1 net016 VIN2 IB1 VSS nfet_03v3 w=0.5u l=0.84u
MM2_f2 net016 VIN2 IB1 VSS nfet_03v3 w=0.5u l=0.84u
MM2_f3 net016 VIN2 IB1 VSS nfet_03v3 w=0.5u l=0.84u
MM3_f0 net04 VB1 net018 VSS nfet_03v3 w=0.5u l=0.84u
MM3_f1 net04 VB1 net018 VSS nfet_03v3 w=0.5u l=0.84u
MM3_f2 net04 VB1 net018 VSS nfet_03v3 w=0.5u l=0.84u
MM3_f3 net04 VB1 net018 VSS nfet_03v3 w=0.5u l=0.84u
MM4_f0 VOUT1 VB1 net016 VSS nfet_03v3 w=0.5u l=0.84u
MM4_f1 VOUT1 VB1 net016 VSS nfet_03v3 w=0.5u l=0.84u
MM4_f2 VOUT1 VB1 net016 VSS nfet_03v3 w=0.5u l=0.84u
MM4_f3 VOUT1 VB1 net016 VSS nfet_03v3 w=0.5u l=0.84u
MM5_f0 net04 net04 net019 VDD pfet_03v3 w=0.5u l=0.84u
MM5_f1 net04 net04 net019 VDD pfet_03v3 w=0.5u l=0.84u
MM5_f2 net04 net04 net019 VDD pfet_03v3 w=0.5u l=0.84u
MM5_f3 net04 net04 net019 VDD pfet_03v3 w=0.5u l=0.84u
MM6_f0 VOUT1 net04 net017 VDD pfet_03v3 w=0.5u l=0.84u
MM6_f1 VOUT1 net04 net017 VDD pfet_03v3 w=0.5u l=0.84u
MM6_f2 VOUT1 net04 net017 VDD pfet_03v3 w=0.5u l=0.84u
MM6_f3 VOUT1 net04 net017 VDD pfet_03v3 w=0.5u l=0.84u
MM7_f0 net019 net019 VDD VDD pfet_03v3 w=0.5u l=0.84u
MM7_f1 net019 net019 VDD VDD pfet_03v3 w=0.5u l=0.84u
MM7_f2 net019 net019 VDD VDD pfet_03v3 w=0.5u l=0.84u
MM7_f3 net019 net019 VDD VDD pfet_03v3 w=0.5u l=0.84u
MM8_f0 net017 net019 VDD VDD pfet_03v3 w=0.5u l=0.84u
MM8_f1 net017 net019 VDD VDD pfet_03v3 w=0.5u l=0.84u
MM8_f2 net017 net019 VDD VDD pfet_03v3 w=0.5u l=0.84u
MM8_f3 net017 net019 VDD VDD pfet_03v3 w=0.5u l=0.84u
.ends C09_gf180_sW0.5_sL1.5
