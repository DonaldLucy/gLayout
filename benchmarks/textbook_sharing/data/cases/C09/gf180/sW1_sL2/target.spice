.subckt C09_gf180_sW1_sL2 VDD VSS VIN1 VIN2 VOUT1 VB1 IB1
MM1 net018 VIN1 IB1 VSS nfet_03v3 w=4u l=1.12u nf=8 m=1
MM2 net016 VIN2 IB1 VSS nfet_03v3 w=4u l=1.12u nf=8 m=1
MM3 net04 VB1 net018 VSS nfet_03v3 w=4u l=1.12u nf=8 m=1
MM4 VOUT1 VB1 net016 VSS nfet_03v3 w=4u l=1.12u nf=8 m=1
MM5 net04 net04 net019 VDD pfet_03v3 w=4u l=1.12u nf=8 m=1
MM6 VOUT1 net04 net017 VDD pfet_03v3 w=4u l=1.12u nf=8 m=1
MM7 net019 net019 VDD VDD pfet_03v3 w=4u l=1.12u nf=8 m=1
MM8 net017 net019 VDD VDD pfet_03v3 w=4u l=1.12u nf=8 m=1
.ends C09_gf180_sW1_sL2
