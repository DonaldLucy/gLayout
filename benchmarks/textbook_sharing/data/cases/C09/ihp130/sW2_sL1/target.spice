.subckt C09_ihp130_sW2_sL1 VDD VSS VIN1 VIN2 VOUT1 VB1 IB1
XM1 net018 VIN1 IB1 VSS sg13_lv_nmos w=16u l=0.26u ng=32 m=1
XM2 net016 VIN2 IB1 VSS sg13_lv_nmos w=16u l=0.26u ng=32 m=1
XM3 net04 VB1 net018 VSS sg13_lv_nmos w=16u l=0.26u ng=32 m=1
XM4 VOUT1 VB1 net016 VSS sg13_lv_nmos w=16u l=0.26u ng=32 m=1
XM5 net04 net04 net019 VDD sg13_lv_pmos w=32u l=0.26u ng=64 m=1
XM6 VOUT1 net04 net017 VDD sg13_lv_pmos w=32u l=0.26u ng=64 m=1
XM7 net019 net019 VDD VDD sg13_lv_pmos w=32u l=0.26u ng=64 m=1
XM8 net017 net019 VDD VDD sg13_lv_pmos w=32u l=0.26u ng=64 m=1
.ends C09_ihp130_sW2_sL1
