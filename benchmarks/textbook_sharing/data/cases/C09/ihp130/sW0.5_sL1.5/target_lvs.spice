.subckt C09_ihp130_sW0.5_sL1.5 VDD VSS VIN1 VIN2 VOUT1 VB1 IB1
XM1_f0 net018 VIN1 IB1 VSS sg13_lv_nmos w=0.5u l=0.39u
XM1_f1 net018 VIN1 IB1 VSS sg13_lv_nmos w=0.5u l=0.39u
XM1_f2 net018 VIN1 IB1 VSS sg13_lv_nmos w=0.5u l=0.39u
XM1_f3 net018 VIN1 IB1 VSS sg13_lv_nmos w=0.5u l=0.39u
XM1_f4 net018 VIN1 IB1 VSS sg13_lv_nmos w=0.5u l=0.39u
XM1_f5 net018 VIN1 IB1 VSS sg13_lv_nmos w=0.5u l=0.39u
XM1_f6 net018 VIN1 IB1 VSS sg13_lv_nmos w=0.5u l=0.39u
XM1_f7 net018 VIN1 IB1 VSS sg13_lv_nmos w=0.5u l=0.39u
XM2_f0 net016 VIN2 IB1 VSS sg13_lv_nmos w=0.5u l=0.39u
XM2_f1 net016 VIN2 IB1 VSS sg13_lv_nmos w=0.5u l=0.39u
XM2_f2 net016 VIN2 IB1 VSS sg13_lv_nmos w=0.5u l=0.39u
XM2_f3 net016 VIN2 IB1 VSS sg13_lv_nmos w=0.5u l=0.39u
XM2_f4 net016 VIN2 IB1 VSS sg13_lv_nmos w=0.5u l=0.39u
XM2_f5 net016 VIN2 IB1 VSS sg13_lv_nmos w=0.5u l=0.39u
XM2_f6 net016 VIN2 IB1 VSS sg13_lv_nmos w=0.5u l=0.39u
XM2_f7 net016 VIN2 IB1 VSS sg13_lv_nmos w=0.5u l=0.39u
XM3_f0 net04 VB1 net018 VSS sg13_lv_nmos w=0.5u l=0.39u
XM3_f1 net04 VB1 net018 VSS sg13_lv_nmos w=0.5u l=0.39u
XM3_f2 net04 VB1 net018 VSS sg13_lv_nmos w=0.5u l=0.39u
XM3_f3 net04 VB1 net018 VSS sg13_lv_nmos w=0.5u l=0.39u
XM3_f4 net04 VB1 net018 VSS sg13_lv_nmos w=0.5u l=0.39u
XM3_f5 net04 VB1 net018 VSS sg13_lv_nmos w=0.5u l=0.39u
XM3_f6 net04 VB1 net018 VSS sg13_lv_nmos w=0.5u l=0.39u
XM3_f7 net04 VB1 net018 VSS sg13_lv_nmos w=0.5u l=0.39u
XM4_f0 VOUT1 VB1 net016 VSS sg13_lv_nmos w=0.5u l=0.39u
XM4_f1 VOUT1 VB1 net016 VSS sg13_lv_nmos w=0.5u l=0.39u
XM4_f2 VOUT1 VB1 net016 VSS sg13_lv_nmos w=0.5u l=0.39u
XM4_f3 VOUT1 VB1 net016 VSS sg13_lv_nmos w=0.5u l=0.39u
XM4_f4 VOUT1 VB1 net016 VSS sg13_lv_nmos w=0.5u l=0.39u
XM4_f5 VOUT1 VB1 net016 VSS sg13_lv_nmos w=0.5u l=0.39u
XM4_f6 VOUT1 VB1 net016 VSS sg13_lv_nmos w=0.5u l=0.39u
XM4_f7 VOUT1 VB1 net016 VSS sg13_lv_nmos w=0.5u l=0.39u
XM5_f0 net04 net04 net019 VDD sg13_lv_pmos w=0.5u l=0.39u
XM5_f1 net04 net04 net019 VDD sg13_lv_pmos w=0.5u l=0.39u
XM5_f2 net04 net04 net019 VDD sg13_lv_pmos w=0.5u l=0.39u
XM5_f3 net04 net04 net019 VDD sg13_lv_pmos w=0.5u l=0.39u
XM5_f4 net04 net04 net019 VDD sg13_lv_pmos w=0.5u l=0.39u
XM5_f5 net04 net04 net019 VDD sg13_lv_pmos w=0.5u l=0.39u
XM5_f6 net04 net04 net019 VDD sg13_lv_pmos w=0.5u l=0.39u
XM5_f7 net04 net04 net019 VDD sg13_lv_pmos w=0.5u l=0.39u
XM5_f8 net04 net04 net019 VDD sg13_lv_pmos w=0.5u l=0.39u
XM5_f9 net04 net04 net019 VDD sg13_lv_pmos w=0.5u l=0.39u
XM5_f10 net04 net04 net019 VDD sg13_lv_pmos w=0.5u l=0.39u
XM5_f11 net04 net04 net019 VDD sg13_lv_pmos w=0.5u l=0.39u
XM5_f12 net04 net04 net019 VDD sg13_lv_pmos w=0.5u l=0.39u
XM5_f13 net04 net04 net019 VDD sg13_lv_pmos w=0.5u l=0.39u
XM5_f14 net04 net04 net019 VDD sg13_lv_pmos w=0.5u l=0.39u
XM5_f15 net04 net04 net019 VDD sg13_lv_pmos w=0.5u l=0.39u
XM6_f0 VOUT1 net04 net017 VDD sg13_lv_pmos w=0.5u l=0.39u
XM6_f1 VOUT1 net04 net017 VDD sg13_lv_pmos w=0.5u l=0.39u
XM6_f2 VOUT1 net04 net017 VDD sg13_lv_pmos w=0.5u l=0.39u
XM6_f3 VOUT1 net04 net017 VDD sg13_lv_pmos w=0.5u l=0.39u
XM6_f4 VOUT1 net04 net017 VDD sg13_lv_pmos w=0.5u l=0.39u
XM6_f5 VOUT1 net04 net017 VDD sg13_lv_pmos w=0.5u l=0.39u
XM6_f6 VOUT1 net04 net017 VDD sg13_lv_pmos w=0.5u l=0.39u
XM6_f7 VOUT1 net04 net017 VDD sg13_lv_pmos w=0.5u l=0.39u
XM6_f8 VOUT1 net04 net017 VDD sg13_lv_pmos w=0.5u l=0.39u
XM6_f9 VOUT1 net04 net017 VDD sg13_lv_pmos w=0.5u l=0.39u
XM6_f10 VOUT1 net04 net017 VDD sg13_lv_pmos w=0.5u l=0.39u
XM6_f11 VOUT1 net04 net017 VDD sg13_lv_pmos w=0.5u l=0.39u
XM6_f12 VOUT1 net04 net017 VDD sg13_lv_pmos w=0.5u l=0.39u
XM6_f13 VOUT1 net04 net017 VDD sg13_lv_pmos w=0.5u l=0.39u
XM6_f14 VOUT1 net04 net017 VDD sg13_lv_pmos w=0.5u l=0.39u
XM6_f15 VOUT1 net04 net017 VDD sg13_lv_pmos w=0.5u l=0.39u
XM7_f0 net019 net019 VDD VDD sg13_lv_pmos w=0.5u l=0.39u
XM7_f1 net019 net019 VDD VDD sg13_lv_pmos w=0.5u l=0.39u
XM7_f2 net019 net019 VDD VDD sg13_lv_pmos w=0.5u l=0.39u
XM7_f3 net019 net019 VDD VDD sg13_lv_pmos w=0.5u l=0.39u
XM7_f4 net019 net019 VDD VDD sg13_lv_pmos w=0.5u l=0.39u
XM7_f5 net019 net019 VDD VDD sg13_lv_pmos w=0.5u l=0.39u
XM7_f6 net019 net019 VDD VDD sg13_lv_pmos w=0.5u l=0.39u
XM7_f7 net019 net019 VDD VDD sg13_lv_pmos w=0.5u l=0.39u
XM7_f8 net019 net019 VDD VDD sg13_lv_pmos w=0.5u l=0.39u
XM7_f9 net019 net019 VDD VDD sg13_lv_pmos w=0.5u l=0.39u
XM7_f10 net019 net019 VDD VDD sg13_lv_pmos w=0.5u l=0.39u
XM7_f11 net019 net019 VDD VDD sg13_lv_pmos w=0.5u l=0.39u
XM7_f12 net019 net019 VDD VDD sg13_lv_pmos w=0.5u l=0.39u
XM7_f13 net019 net019 VDD VDD sg13_lv_pmos w=0.5u l=0.39u
XM7_f14 net019 net019 VDD VDD sg13_lv_pmos w=0.5u l=0.39u
XM7_f15 net019 net019 VDD VDD sg13_lv_pmos w=0.5u l=0.39u
XM8_f0 net017 net019 VDD VDD sg13_lv_pmos w=0.5u l=0.39u
XM8_f1 net017 net019 VDD VDD sg13_lv_pmos w=0.5u l=0.39u
XM8_f2 net017 net019 VDD VDD sg13_lv_pmos w=0.5u l=0.39u
XM8_f3 net017 net019 VDD VDD sg13_lv_pmos w=0.5u l=0.39u
XM8_f4 net017 net019 VDD VDD sg13_lv_pmos w=0.5u l=0.39u
XM8_f5 net017 net019 VDD VDD sg13_lv_pmos w=0.5u l=0.39u
XM8_f6 net017 net019 VDD VDD sg13_lv_pmos w=0.5u l=0.39u
XM8_f7 net017 net019 VDD VDD sg13_lv_pmos w=0.5u l=0.39u
XM8_f8 net017 net019 VDD VDD sg13_lv_pmos w=0.5u l=0.39u
XM8_f9 net017 net019 VDD VDD sg13_lv_pmos w=0.5u l=0.39u
XM8_f10 net017 net019 VDD VDD sg13_lv_pmos w=0.5u l=0.39u
XM8_f11 net017 net019 VDD VDD sg13_lv_pmos w=0.5u l=0.39u
XM8_f12 net017 net019 VDD VDD sg13_lv_pmos w=0.5u l=0.39u
XM8_f13 net017 net019 VDD VDD sg13_lv_pmos w=0.5u l=0.39u
XM8_f14 net017 net019 VDD VDD sg13_lv_pmos w=0.5u l=0.39u
XM8_f15 net017 net019 VDD VDD sg13_lv_pmos w=0.5u l=0.39u
.ends C09_ihp130_sW0.5_sL1.5
