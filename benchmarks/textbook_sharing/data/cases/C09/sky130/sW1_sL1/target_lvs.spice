.subckt C09_sky130_sW1_sL1 VDD VSS VIN1 VIN2 VOUT1 VB1 IB1
XM1_f0 net018 VIN1 IB1 VSS sky130_fd_pr__nfet_01v8 w=0.5 l=0.3
XM1_f1 net018 VIN1 IB1 VSS sky130_fd_pr__nfet_01v8 w=0.5 l=0.3
XM1_f2 net018 VIN1 IB1 VSS sky130_fd_pr__nfet_01v8 w=0.5 l=0.3
XM1_f3 net018 VIN1 IB1 VSS sky130_fd_pr__nfet_01v8 w=0.5 l=0.3
XM1_f4 net018 VIN1 IB1 VSS sky130_fd_pr__nfet_01v8 w=0.5 l=0.3
XM1_f5 net018 VIN1 IB1 VSS sky130_fd_pr__nfet_01v8 w=0.5 l=0.3
XM1_f6 net018 VIN1 IB1 VSS sky130_fd_pr__nfet_01v8 w=0.5 l=0.3
XM1_f7 net018 VIN1 IB1 VSS sky130_fd_pr__nfet_01v8 w=0.5 l=0.3
XM1_f8 net018 VIN1 IB1 VSS sky130_fd_pr__nfet_01v8 w=0.5 l=0.3
XM1_f9 net018 VIN1 IB1 VSS sky130_fd_pr__nfet_01v8 w=0.5 l=0.3
XM1_f10 net018 VIN1 IB1 VSS sky130_fd_pr__nfet_01v8 w=0.5 l=0.3
XM1_f11 net018 VIN1 IB1 VSS sky130_fd_pr__nfet_01v8 w=0.5 l=0.3
XM1_f12 net018 VIN1 IB1 VSS sky130_fd_pr__nfet_01v8 w=0.5 l=0.3
XM1_f13 net018 VIN1 IB1 VSS sky130_fd_pr__nfet_01v8 w=0.5 l=0.3
XM1_f14 net018 VIN1 IB1 VSS sky130_fd_pr__nfet_01v8 w=0.5 l=0.3
XM1_f15 net018 VIN1 IB1 VSS sky130_fd_pr__nfet_01v8 w=0.5 l=0.3
XM2_f0 net016 VIN2 IB1 VSS sky130_fd_pr__nfet_01v8 w=0.5 l=0.3
XM2_f1 net016 VIN2 IB1 VSS sky130_fd_pr__nfet_01v8 w=0.5 l=0.3
XM2_f2 net016 VIN2 IB1 VSS sky130_fd_pr__nfet_01v8 w=0.5 l=0.3
XM2_f3 net016 VIN2 IB1 VSS sky130_fd_pr__nfet_01v8 w=0.5 l=0.3
XM2_f4 net016 VIN2 IB1 VSS sky130_fd_pr__nfet_01v8 w=0.5 l=0.3
XM2_f5 net016 VIN2 IB1 VSS sky130_fd_pr__nfet_01v8 w=0.5 l=0.3
XM2_f6 net016 VIN2 IB1 VSS sky130_fd_pr__nfet_01v8 w=0.5 l=0.3
XM2_f7 net016 VIN2 IB1 VSS sky130_fd_pr__nfet_01v8 w=0.5 l=0.3
XM2_f8 net016 VIN2 IB1 VSS sky130_fd_pr__nfet_01v8 w=0.5 l=0.3
XM2_f9 net016 VIN2 IB1 VSS sky130_fd_pr__nfet_01v8 w=0.5 l=0.3
XM2_f10 net016 VIN2 IB1 VSS sky130_fd_pr__nfet_01v8 w=0.5 l=0.3
XM2_f11 net016 VIN2 IB1 VSS sky130_fd_pr__nfet_01v8 w=0.5 l=0.3
XM2_f12 net016 VIN2 IB1 VSS sky130_fd_pr__nfet_01v8 w=0.5 l=0.3
XM2_f13 net016 VIN2 IB1 VSS sky130_fd_pr__nfet_01v8 w=0.5 l=0.3
XM2_f14 net016 VIN2 IB1 VSS sky130_fd_pr__nfet_01v8 w=0.5 l=0.3
XM2_f15 net016 VIN2 IB1 VSS sky130_fd_pr__nfet_01v8 w=0.5 l=0.3
XM3_f0 net04 VB1 net018 VSS sky130_fd_pr__nfet_01v8 w=0.5 l=0.3
XM3_f1 net04 VB1 net018 VSS sky130_fd_pr__nfet_01v8 w=0.5 l=0.3
XM3_f2 net04 VB1 net018 VSS sky130_fd_pr__nfet_01v8 w=0.5 l=0.3
XM3_f3 net04 VB1 net018 VSS sky130_fd_pr__nfet_01v8 w=0.5 l=0.3
XM3_f4 net04 VB1 net018 VSS sky130_fd_pr__nfet_01v8 w=0.5 l=0.3
XM3_f5 net04 VB1 net018 VSS sky130_fd_pr__nfet_01v8 w=0.5 l=0.3
XM3_f6 net04 VB1 net018 VSS sky130_fd_pr__nfet_01v8 w=0.5 l=0.3
XM3_f7 net04 VB1 net018 VSS sky130_fd_pr__nfet_01v8 w=0.5 l=0.3
XM3_f8 net04 VB1 net018 VSS sky130_fd_pr__nfet_01v8 w=0.5 l=0.3
XM3_f9 net04 VB1 net018 VSS sky130_fd_pr__nfet_01v8 w=0.5 l=0.3
XM3_f10 net04 VB1 net018 VSS sky130_fd_pr__nfet_01v8 w=0.5 l=0.3
XM3_f11 net04 VB1 net018 VSS sky130_fd_pr__nfet_01v8 w=0.5 l=0.3
XM3_f12 net04 VB1 net018 VSS sky130_fd_pr__nfet_01v8 w=0.5 l=0.3
XM3_f13 net04 VB1 net018 VSS sky130_fd_pr__nfet_01v8 w=0.5 l=0.3
XM3_f14 net04 VB1 net018 VSS sky130_fd_pr__nfet_01v8 w=0.5 l=0.3
XM3_f15 net04 VB1 net018 VSS sky130_fd_pr__nfet_01v8 w=0.5 l=0.3
XM4_f0 VOUT1 VB1 net016 VSS sky130_fd_pr__nfet_01v8 w=0.5 l=0.3
XM4_f1 VOUT1 VB1 net016 VSS sky130_fd_pr__nfet_01v8 w=0.5 l=0.3
XM4_f2 VOUT1 VB1 net016 VSS sky130_fd_pr__nfet_01v8 w=0.5 l=0.3
XM4_f3 VOUT1 VB1 net016 VSS sky130_fd_pr__nfet_01v8 w=0.5 l=0.3
XM4_f4 VOUT1 VB1 net016 VSS sky130_fd_pr__nfet_01v8 w=0.5 l=0.3
XM4_f5 VOUT1 VB1 net016 VSS sky130_fd_pr__nfet_01v8 w=0.5 l=0.3
XM4_f6 VOUT1 VB1 net016 VSS sky130_fd_pr__nfet_01v8 w=0.5 l=0.3
XM4_f7 VOUT1 VB1 net016 VSS sky130_fd_pr__nfet_01v8 w=0.5 l=0.3
XM4_f8 VOUT1 VB1 net016 VSS sky130_fd_pr__nfet_01v8 w=0.5 l=0.3
XM4_f9 VOUT1 VB1 net016 VSS sky130_fd_pr__nfet_01v8 w=0.5 l=0.3
XM4_f10 VOUT1 VB1 net016 VSS sky130_fd_pr__nfet_01v8 w=0.5 l=0.3
XM4_f11 VOUT1 VB1 net016 VSS sky130_fd_pr__nfet_01v8 w=0.5 l=0.3
XM4_f12 VOUT1 VB1 net016 VSS sky130_fd_pr__nfet_01v8 w=0.5 l=0.3
XM4_f13 VOUT1 VB1 net016 VSS sky130_fd_pr__nfet_01v8 w=0.5 l=0.3
XM4_f14 VOUT1 VB1 net016 VSS sky130_fd_pr__nfet_01v8 w=0.5 l=0.3
XM4_f15 VOUT1 VB1 net016 VSS sky130_fd_pr__nfet_01v8 w=0.5 l=0.3
XM5_f0 net04 net04 net019 VDD sky130_fd_pr__pfet_01v8 w=0.5 l=0.3
XM5_f1 net04 net04 net019 VDD sky130_fd_pr__pfet_01v8 w=0.5 l=0.3
XM5_f2 net04 net04 net019 VDD sky130_fd_pr__pfet_01v8 w=0.5 l=0.3
XM5_f3 net04 net04 net019 VDD sky130_fd_pr__pfet_01v8 w=0.5 l=0.3
XM5_f4 net04 net04 net019 VDD sky130_fd_pr__pfet_01v8 w=0.5 l=0.3
XM5_f5 net04 net04 net019 VDD sky130_fd_pr__pfet_01v8 w=0.5 l=0.3
XM5_f6 net04 net04 net019 VDD sky130_fd_pr__pfet_01v8 w=0.5 l=0.3
XM5_f7 net04 net04 net019 VDD sky130_fd_pr__pfet_01v8 w=0.5 l=0.3
XM5_f8 net04 net04 net019 VDD sky130_fd_pr__pfet_01v8 w=0.5 l=0.3
XM5_f9 net04 net04 net019 VDD sky130_fd_pr__pfet_01v8 w=0.5 l=0.3
XM5_f10 net04 net04 net019 VDD sky130_fd_pr__pfet_01v8 w=0.5 l=0.3
XM5_f11 net04 net04 net019 VDD sky130_fd_pr__pfet_01v8 w=0.5 l=0.3
XM5_f12 net04 net04 net019 VDD sky130_fd_pr__pfet_01v8 w=0.5 l=0.3
XM5_f13 net04 net04 net019 VDD sky130_fd_pr__pfet_01v8 w=0.5 l=0.3
XM5_f14 net04 net04 net019 VDD sky130_fd_pr__pfet_01v8 w=0.5 l=0.3
XM5_f15 net04 net04 net019 VDD sky130_fd_pr__pfet_01v8 w=0.5 l=0.3
XM5_f16 net04 net04 net019 VDD sky130_fd_pr__pfet_01v8 w=0.5 l=0.3
XM5_f17 net04 net04 net019 VDD sky130_fd_pr__pfet_01v8 w=0.5 l=0.3
XM5_f18 net04 net04 net019 VDD sky130_fd_pr__pfet_01v8 w=0.5 l=0.3
XM5_f19 net04 net04 net019 VDD sky130_fd_pr__pfet_01v8 w=0.5 l=0.3
XM5_f20 net04 net04 net019 VDD sky130_fd_pr__pfet_01v8 w=0.5 l=0.3
XM5_f21 net04 net04 net019 VDD sky130_fd_pr__pfet_01v8 w=0.5 l=0.3
XM5_f22 net04 net04 net019 VDD sky130_fd_pr__pfet_01v8 w=0.5 l=0.3
XM5_f23 net04 net04 net019 VDD sky130_fd_pr__pfet_01v8 w=0.5 l=0.3
XM5_f24 net04 net04 net019 VDD sky130_fd_pr__pfet_01v8 w=0.5 l=0.3
XM5_f25 net04 net04 net019 VDD sky130_fd_pr__pfet_01v8 w=0.5 l=0.3
XM5_f26 net04 net04 net019 VDD sky130_fd_pr__pfet_01v8 w=0.5 l=0.3
XM5_f27 net04 net04 net019 VDD sky130_fd_pr__pfet_01v8 w=0.5 l=0.3
XM5_f28 net04 net04 net019 VDD sky130_fd_pr__pfet_01v8 w=0.5 l=0.3
XM5_f29 net04 net04 net019 VDD sky130_fd_pr__pfet_01v8 w=0.5 l=0.3
XM5_f30 net04 net04 net019 VDD sky130_fd_pr__pfet_01v8 w=0.5 l=0.3
XM5_f31 net04 net04 net019 VDD sky130_fd_pr__pfet_01v8 w=0.5 l=0.3
XM6_f0 VOUT1 net04 net017 VDD sky130_fd_pr__pfet_01v8 w=0.5 l=0.3
XM6_f1 VOUT1 net04 net017 VDD sky130_fd_pr__pfet_01v8 w=0.5 l=0.3
XM6_f2 VOUT1 net04 net017 VDD sky130_fd_pr__pfet_01v8 w=0.5 l=0.3
XM6_f3 VOUT1 net04 net017 VDD sky130_fd_pr__pfet_01v8 w=0.5 l=0.3
XM6_f4 VOUT1 net04 net017 VDD sky130_fd_pr__pfet_01v8 w=0.5 l=0.3
XM6_f5 VOUT1 net04 net017 VDD sky130_fd_pr__pfet_01v8 w=0.5 l=0.3
XM6_f6 VOUT1 net04 net017 VDD sky130_fd_pr__pfet_01v8 w=0.5 l=0.3
XM6_f7 VOUT1 net04 net017 VDD sky130_fd_pr__pfet_01v8 w=0.5 l=0.3
XM6_f8 VOUT1 net04 net017 VDD sky130_fd_pr__pfet_01v8 w=0.5 l=0.3
XM6_f9 VOUT1 net04 net017 VDD sky130_fd_pr__pfet_01v8 w=0.5 l=0.3
XM6_f10 VOUT1 net04 net017 VDD sky130_fd_pr__pfet_01v8 w=0.5 l=0.3
XM6_f11 VOUT1 net04 net017 VDD sky130_fd_pr__pfet_01v8 w=0.5 l=0.3
XM6_f12 VOUT1 net04 net017 VDD sky130_fd_pr__pfet_01v8 w=0.5 l=0.3
XM6_f13 VOUT1 net04 net017 VDD sky130_fd_pr__pfet_01v8 w=0.5 l=0.3
XM6_f14 VOUT1 net04 net017 VDD sky130_fd_pr__pfet_01v8 w=0.5 l=0.3
XM6_f15 VOUT1 net04 net017 VDD sky130_fd_pr__pfet_01v8 w=0.5 l=0.3
XM6_f16 VOUT1 net04 net017 VDD sky130_fd_pr__pfet_01v8 w=0.5 l=0.3
XM6_f17 VOUT1 net04 net017 VDD sky130_fd_pr__pfet_01v8 w=0.5 l=0.3
XM6_f18 VOUT1 net04 net017 VDD sky130_fd_pr__pfet_01v8 w=0.5 l=0.3
XM6_f19 VOUT1 net04 net017 VDD sky130_fd_pr__pfet_01v8 w=0.5 l=0.3
XM6_f20 VOUT1 net04 net017 VDD sky130_fd_pr__pfet_01v8 w=0.5 l=0.3
XM6_f21 VOUT1 net04 net017 VDD sky130_fd_pr__pfet_01v8 w=0.5 l=0.3
XM6_f22 VOUT1 net04 net017 VDD sky130_fd_pr__pfet_01v8 w=0.5 l=0.3
XM6_f23 VOUT1 net04 net017 VDD sky130_fd_pr__pfet_01v8 w=0.5 l=0.3
XM6_f24 VOUT1 net04 net017 VDD sky130_fd_pr__pfet_01v8 w=0.5 l=0.3
XM6_f25 VOUT1 net04 net017 VDD sky130_fd_pr__pfet_01v8 w=0.5 l=0.3
XM6_f26 VOUT1 net04 net017 VDD sky130_fd_pr__pfet_01v8 w=0.5 l=0.3
XM6_f27 VOUT1 net04 net017 VDD sky130_fd_pr__pfet_01v8 w=0.5 l=0.3
XM6_f28 VOUT1 net04 net017 VDD sky130_fd_pr__pfet_01v8 w=0.5 l=0.3
XM6_f29 VOUT1 net04 net017 VDD sky130_fd_pr__pfet_01v8 w=0.5 l=0.3
XM6_f30 VOUT1 net04 net017 VDD sky130_fd_pr__pfet_01v8 w=0.5 l=0.3
XM6_f31 VOUT1 net04 net017 VDD sky130_fd_pr__pfet_01v8 w=0.5 l=0.3
XM7_f0 net019 net019 VDD VDD sky130_fd_pr__pfet_01v8 w=0.5 l=0.3
XM7_f1 net019 net019 VDD VDD sky130_fd_pr__pfet_01v8 w=0.5 l=0.3
XM7_f2 net019 net019 VDD VDD sky130_fd_pr__pfet_01v8 w=0.5 l=0.3
XM7_f3 net019 net019 VDD VDD sky130_fd_pr__pfet_01v8 w=0.5 l=0.3
XM7_f4 net019 net019 VDD VDD sky130_fd_pr__pfet_01v8 w=0.5 l=0.3
XM7_f5 net019 net019 VDD VDD sky130_fd_pr__pfet_01v8 w=0.5 l=0.3
XM7_f6 net019 net019 VDD VDD sky130_fd_pr__pfet_01v8 w=0.5 l=0.3
XM7_f7 net019 net019 VDD VDD sky130_fd_pr__pfet_01v8 w=0.5 l=0.3
XM7_f8 net019 net019 VDD VDD sky130_fd_pr__pfet_01v8 w=0.5 l=0.3
XM7_f9 net019 net019 VDD VDD sky130_fd_pr__pfet_01v8 w=0.5 l=0.3
XM7_f10 net019 net019 VDD VDD sky130_fd_pr__pfet_01v8 w=0.5 l=0.3
XM7_f11 net019 net019 VDD VDD sky130_fd_pr__pfet_01v8 w=0.5 l=0.3
XM7_f12 net019 net019 VDD VDD sky130_fd_pr__pfet_01v8 w=0.5 l=0.3
XM7_f13 net019 net019 VDD VDD sky130_fd_pr__pfet_01v8 w=0.5 l=0.3
XM7_f14 net019 net019 VDD VDD sky130_fd_pr__pfet_01v8 w=0.5 l=0.3
XM7_f15 net019 net019 VDD VDD sky130_fd_pr__pfet_01v8 w=0.5 l=0.3
XM7_f16 net019 net019 VDD VDD sky130_fd_pr__pfet_01v8 w=0.5 l=0.3
XM7_f17 net019 net019 VDD VDD sky130_fd_pr__pfet_01v8 w=0.5 l=0.3
XM7_f18 net019 net019 VDD VDD sky130_fd_pr__pfet_01v8 w=0.5 l=0.3
XM7_f19 net019 net019 VDD VDD sky130_fd_pr__pfet_01v8 w=0.5 l=0.3
XM7_f20 net019 net019 VDD VDD sky130_fd_pr__pfet_01v8 w=0.5 l=0.3
XM7_f21 net019 net019 VDD VDD sky130_fd_pr__pfet_01v8 w=0.5 l=0.3
XM7_f22 net019 net019 VDD VDD sky130_fd_pr__pfet_01v8 w=0.5 l=0.3
XM7_f23 net019 net019 VDD VDD sky130_fd_pr__pfet_01v8 w=0.5 l=0.3
XM7_f24 net019 net019 VDD VDD sky130_fd_pr__pfet_01v8 w=0.5 l=0.3
XM7_f25 net019 net019 VDD VDD sky130_fd_pr__pfet_01v8 w=0.5 l=0.3
XM7_f26 net019 net019 VDD VDD sky130_fd_pr__pfet_01v8 w=0.5 l=0.3
XM7_f27 net019 net019 VDD VDD sky130_fd_pr__pfet_01v8 w=0.5 l=0.3
XM7_f28 net019 net019 VDD VDD sky130_fd_pr__pfet_01v8 w=0.5 l=0.3
XM7_f29 net019 net019 VDD VDD sky130_fd_pr__pfet_01v8 w=0.5 l=0.3
XM7_f30 net019 net019 VDD VDD sky130_fd_pr__pfet_01v8 w=0.5 l=0.3
XM7_f31 net019 net019 VDD VDD sky130_fd_pr__pfet_01v8 w=0.5 l=0.3
XM8_f0 net017 net019 VDD VDD sky130_fd_pr__pfet_01v8 w=0.5 l=0.3
XM8_f1 net017 net019 VDD VDD sky130_fd_pr__pfet_01v8 w=0.5 l=0.3
XM8_f2 net017 net019 VDD VDD sky130_fd_pr__pfet_01v8 w=0.5 l=0.3
XM8_f3 net017 net019 VDD VDD sky130_fd_pr__pfet_01v8 w=0.5 l=0.3
XM8_f4 net017 net019 VDD VDD sky130_fd_pr__pfet_01v8 w=0.5 l=0.3
XM8_f5 net017 net019 VDD VDD sky130_fd_pr__pfet_01v8 w=0.5 l=0.3
XM8_f6 net017 net019 VDD VDD sky130_fd_pr__pfet_01v8 w=0.5 l=0.3
XM8_f7 net017 net019 VDD VDD sky130_fd_pr__pfet_01v8 w=0.5 l=0.3
XM8_f8 net017 net019 VDD VDD sky130_fd_pr__pfet_01v8 w=0.5 l=0.3
XM8_f9 net017 net019 VDD VDD sky130_fd_pr__pfet_01v8 w=0.5 l=0.3
XM8_f10 net017 net019 VDD VDD sky130_fd_pr__pfet_01v8 w=0.5 l=0.3
XM8_f11 net017 net019 VDD VDD sky130_fd_pr__pfet_01v8 w=0.5 l=0.3
XM8_f12 net017 net019 VDD VDD sky130_fd_pr__pfet_01v8 w=0.5 l=0.3
XM8_f13 net017 net019 VDD VDD sky130_fd_pr__pfet_01v8 w=0.5 l=0.3
XM8_f14 net017 net019 VDD VDD sky130_fd_pr__pfet_01v8 w=0.5 l=0.3
XM8_f15 net017 net019 VDD VDD sky130_fd_pr__pfet_01v8 w=0.5 l=0.3
XM8_f16 net017 net019 VDD VDD sky130_fd_pr__pfet_01v8 w=0.5 l=0.3
XM8_f17 net017 net019 VDD VDD sky130_fd_pr__pfet_01v8 w=0.5 l=0.3
XM8_f18 net017 net019 VDD VDD sky130_fd_pr__pfet_01v8 w=0.5 l=0.3
XM8_f19 net017 net019 VDD VDD sky130_fd_pr__pfet_01v8 w=0.5 l=0.3
XM8_f20 net017 net019 VDD VDD sky130_fd_pr__pfet_01v8 w=0.5 l=0.3
XM8_f21 net017 net019 VDD VDD sky130_fd_pr__pfet_01v8 w=0.5 l=0.3
XM8_f22 net017 net019 VDD VDD sky130_fd_pr__pfet_01v8 w=0.5 l=0.3
XM8_f23 net017 net019 VDD VDD sky130_fd_pr__pfet_01v8 w=0.5 l=0.3
XM8_f24 net017 net019 VDD VDD sky130_fd_pr__pfet_01v8 w=0.5 l=0.3
XM8_f25 net017 net019 VDD VDD sky130_fd_pr__pfet_01v8 w=0.5 l=0.3
XM8_f26 net017 net019 VDD VDD sky130_fd_pr__pfet_01v8 w=0.5 l=0.3
XM8_f27 net017 net019 VDD VDD sky130_fd_pr__pfet_01v8 w=0.5 l=0.3
XM8_f28 net017 net019 VDD VDD sky130_fd_pr__pfet_01v8 w=0.5 l=0.3
XM8_f29 net017 net019 VDD VDD sky130_fd_pr__pfet_01v8 w=0.5 l=0.3
XM8_f30 net017 net019 VDD VDD sky130_fd_pr__pfet_01v8 w=0.5 l=0.3
XM8_f31 net017 net019 VDD VDD sky130_fd_pr__pfet_01v8 w=0.5 l=0.3
.ends C09_sky130_sW1_sL1
