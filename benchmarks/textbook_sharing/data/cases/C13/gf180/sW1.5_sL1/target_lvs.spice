.subckt C13_gf180_sW1.5_sL1 VSS IIN1 IOUT1 IB1
MM1_f0 IB1 IB1 VSS VSS nfet_03v3 w=0.75u l=0.56u
MM2_f0 IIN1 IB1 net15 VSS nfet_03v3 w=0.75u l=0.56u
MM2_f1 IIN1 IB1 net15 VSS nfet_03v3 w=0.75u l=0.56u
MM2_f2 IIN1 IB1 net15 VSS nfet_03v3 w=0.75u l=0.56u
MM2_f3 IIN1 IB1 net15 VSS nfet_03v3 w=0.75u l=0.56u
MM3_f0 net15 IIN1 VSS VSS nfet_03v3 w=0.75u l=0.56u
MM3_f1 net15 IIN1 VSS VSS nfet_03v3 w=0.75u l=0.56u
MM3_f2 net15 IIN1 VSS VSS nfet_03v3 w=0.75u l=0.56u
MM3_f3 net15 IIN1 VSS VSS nfet_03v3 w=0.75u l=0.56u
MM4_f0 IOUT1 IB1 net14 VSS nfet_03v3 w=0.75u l=0.56u
MM4_f1 IOUT1 IB1 net14 VSS nfet_03v3 w=0.75u l=0.56u
MM4_f2 IOUT1 IB1 net14 VSS nfet_03v3 w=0.75u l=0.56u
MM4_f3 IOUT1 IB1 net14 VSS nfet_03v3 w=0.75u l=0.56u
MM5_f0 net14 IIN1 VSS VSS nfet_03v3 w=0.75u l=0.56u
MM5_f1 net14 IIN1 VSS VSS nfet_03v3 w=0.75u l=0.56u
MM5_f2 net14 IIN1 VSS VSS nfet_03v3 w=0.75u l=0.56u
MM5_f3 net14 IIN1 VSS VSS nfet_03v3 w=0.75u l=0.56u
.ends C13_gf180_sW1.5_sL1
