.subckt C13_gf180_sW2_sL1.5 VSS IIN1 IOUT1 IB1
MM1_f0 IB1 IB1 VSS VSS nfet_03v3 w=0.5u l=0.84u
MM1_f1 IB1 IB1 VSS VSS nfet_03v3 w=0.5u l=0.84u
MM2_f0 IIN1 IB1 net15 VSS nfet_03v3 w=0.5u l=0.84u
MM2_f1 IIN1 IB1 net15 VSS nfet_03v3 w=0.5u l=0.84u
MM2_f2 IIN1 IB1 net15 VSS nfet_03v3 w=0.5u l=0.84u
MM2_f3 IIN1 IB1 net15 VSS nfet_03v3 w=0.5u l=0.84u
MM2_f4 IIN1 IB1 net15 VSS nfet_03v3 w=0.5u l=0.84u
MM2_f5 IIN1 IB1 net15 VSS nfet_03v3 w=0.5u l=0.84u
MM2_f6 IIN1 IB1 net15 VSS nfet_03v3 w=0.5u l=0.84u
MM2_f7 IIN1 IB1 net15 VSS nfet_03v3 w=0.5u l=0.84u
MM3_f0 net15 IIN1 VSS VSS nfet_03v3 w=0.5u l=0.84u
MM3_f1 net15 IIN1 VSS VSS nfet_03v3 w=0.5u l=0.84u
MM3_f2 net15 IIN1 VSS VSS nfet_03v3 w=0.5u l=0.84u
MM3_f3 net15 IIN1 VSS VSS nfet_03v3 w=0.5u l=0.84u
MM3_f4 net15 IIN1 VSS VSS nfet_03v3 w=0.5u l=0.84u
MM3_f5 net15 IIN1 VSS VSS nfet_03v3 w=0.5u l=0.84u
MM3_f6 net15 IIN1 VSS VSS nfet_03v3 w=0.5u l=0.84u
MM3_f7 net15 IIN1 VSS VSS nfet_03v3 w=0.5u l=0.84u
MM4_f0 IOUT1 IB1 net14 VSS nfet_03v3 w=0.5u l=0.84u
MM4_f1 IOUT1 IB1 net14 VSS nfet_03v3 w=0.5u l=0.84u
MM4_f2 IOUT1 IB1 net14 VSS nfet_03v3 w=0.5u l=0.84u
MM4_f3 IOUT1 IB1 net14 VSS nfet_03v3 w=0.5u l=0.84u
MM4_f4 IOUT1 IB1 net14 VSS nfet_03v3 w=0.5u l=0.84u
MM4_f5 IOUT1 IB1 net14 VSS nfet_03v3 w=0.5u l=0.84u
MM4_f6 IOUT1 IB1 net14 VSS nfet_03v3 w=0.5u l=0.84u
MM4_f7 IOUT1 IB1 net14 VSS nfet_03v3 w=0.5u l=0.84u
MM5_f0 net14 IIN1 VSS VSS nfet_03v3 w=0.5u l=0.84u
MM5_f1 net14 IIN1 VSS VSS nfet_03v3 w=0.5u l=0.84u
MM5_f2 net14 IIN1 VSS VSS nfet_03v3 w=0.5u l=0.84u
MM5_f3 net14 IIN1 VSS VSS nfet_03v3 w=0.5u l=0.84u
MM5_f4 net14 IIN1 VSS VSS nfet_03v3 w=0.5u l=0.84u
MM5_f5 net14 IIN1 VSS VSS nfet_03v3 w=0.5u l=0.84u
MM5_f6 net14 IIN1 VSS VSS nfet_03v3 w=0.5u l=0.84u
MM5_f7 net14 IIN1 VSS VSS nfet_03v3 w=0.5u l=0.84u
.ends C13_gf180_sW2_sL1.5
