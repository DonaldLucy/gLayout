.subckt C13_sky130_sW1_sL1.5 VSS IIN1 IOUT1 IB1
XM1 IB1 IB1 VSS VSS sky130_fd_pr__nfet_01v8 w=0.5 l=0.45 nf=1
XM2 IIN1 IB1 net15 VSS sky130_fd_pr__nfet_01v8 w=2 l=0.45 nf=4
XM3 net15 IIN1 VSS VSS sky130_fd_pr__nfet_01v8 w=2 l=0.45 nf=4
XM4 IOUT1 IB1 net14 VSS sky130_fd_pr__nfet_01v8 w=2 l=0.45 nf=4
XM5 net14 IIN1 VSS VSS sky130_fd_pr__nfet_01v8 w=2 l=0.45 nf=4
.ends C13_sky130_sW1_sL1.5
