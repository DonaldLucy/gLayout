.subckt C17_gf180_sW2_sL1 VDD VSS VIN1 VIN2 VOUT1 VOUT2 VB1
MM1_f0 VOUT1 VIN1 net07 VSS nfet_03v3 w=0.5u l=0.56u
MM1_f1 VOUT1 VIN1 net07 VSS nfet_03v3 w=0.5u l=0.56u
MM1_f2 VOUT1 VIN1 net07 VSS nfet_03v3 w=0.5u l=0.56u
MM1_f3 VOUT1 VIN1 net07 VSS nfet_03v3 w=0.5u l=0.56u
MM1_f4 VOUT1 VIN1 net07 VSS nfet_03v3 w=0.5u l=0.56u
MM1_f5 VOUT1 VIN1 net07 VSS nfet_03v3 w=0.5u l=0.56u
MM1_f6 VOUT1 VIN1 net07 VSS nfet_03v3 w=0.5u l=0.56u
MM1_f7 VOUT1 VIN1 net07 VSS nfet_03v3 w=0.5u l=0.56u
MM1_f8 VOUT1 VIN1 net07 VSS nfet_03v3 w=0.5u l=0.56u
MM1_f9 VOUT1 VIN1 net07 VSS nfet_03v3 w=0.5u l=0.56u
MM1_f10 VOUT1 VIN1 net07 VSS nfet_03v3 w=0.5u l=0.56u
MM1_f11 VOUT1 VIN1 net07 VSS nfet_03v3 w=0.5u l=0.56u
MM1_f12 VOUT1 VIN1 net07 VSS nfet_03v3 w=0.5u l=0.56u
MM1_f13 VOUT1 VIN1 net07 VSS nfet_03v3 w=0.5u l=0.56u
MM1_f14 VOUT1 VIN1 net07 VSS nfet_03v3 w=0.5u l=0.56u
MM1_f15 VOUT1 VIN1 net07 VSS nfet_03v3 w=0.5u l=0.56u
MM2_f0 VOUT2 VIN2 net09 VSS nfet_03v3 w=0.5u l=0.56u
MM2_f1 VOUT2 VIN2 net09 VSS nfet_03v3 w=0.5u l=0.56u
MM2_f2 VOUT2 VIN2 net09 VSS nfet_03v3 w=0.5u l=0.56u
MM2_f3 VOUT2 VIN2 net09 VSS nfet_03v3 w=0.5u l=0.56u
MM2_f4 VOUT2 VIN2 net09 VSS nfet_03v3 w=0.5u l=0.56u
MM2_f5 VOUT2 VIN2 net09 VSS nfet_03v3 w=0.5u l=0.56u
MM2_f6 VOUT2 VIN2 net09 VSS nfet_03v3 w=0.5u l=0.56u
MM2_f7 VOUT2 VIN2 net09 VSS nfet_03v3 w=0.5u l=0.56u
MM2_f8 VOUT2 VIN2 net09 VSS nfet_03v3 w=0.5u l=0.56u
MM2_f9 VOUT2 VIN2 net09 VSS nfet_03v3 w=0.5u l=0.56u
MM2_f10 VOUT2 VIN2 net09 VSS nfet_03v3 w=0.5u l=0.56u
MM2_f11 VOUT2 VIN2 net09 VSS nfet_03v3 w=0.5u l=0.56u
MM2_f12 VOUT2 VIN2 net09 VSS nfet_03v3 w=0.5u l=0.56u
MM2_f13 VOUT2 VIN2 net09 VSS nfet_03v3 w=0.5u l=0.56u
MM2_f14 VOUT2 VIN2 net09 VSS nfet_03v3 w=0.5u l=0.56u
MM2_f15 VOUT2 VIN2 net09 VSS nfet_03v3 w=0.5u l=0.56u
MM3_f0 net06 VB1 VSS VSS nfet_03v3 w=0.5u l=0.56u
MM3_f1 net06 VB1 VSS VSS nfet_03v3 w=0.5u l=0.56u
MM3_f2 net06 VB1 VSS VSS nfet_03v3 w=0.5u l=0.56u
MM3_f3 net06 VB1 VSS VSS nfet_03v3 w=0.5u l=0.56u
MM3_f4 net06 VB1 VSS VSS nfet_03v3 w=0.5u l=0.56u
MM3_f5 net06 VB1 VSS VSS nfet_03v3 w=0.5u l=0.56u
MM3_f6 net06 VB1 VSS VSS nfet_03v3 w=0.5u l=0.56u
MM3_f7 net06 VB1 VSS VSS nfet_03v3 w=0.5u l=0.56u
MM3_f8 net06 VB1 VSS VSS nfet_03v3 w=0.5u l=0.56u
MM3_f9 net06 VB1 VSS VSS nfet_03v3 w=0.5u l=0.56u
MM3_f10 net06 VB1 VSS VSS nfet_03v3 w=0.5u l=0.56u
MM3_f11 net06 VB1 VSS VSS nfet_03v3 w=0.5u l=0.56u
MM3_f12 net06 VB1 VSS VSS nfet_03v3 w=0.5u l=0.56u
MM3_f13 net06 VB1 VSS VSS nfet_03v3 w=0.5u l=0.56u
MM3_f14 net06 VB1 VSS VSS nfet_03v3 w=0.5u l=0.56u
MM3_f15 net06 VB1 VSS VSS nfet_03v3 w=0.5u l=0.56u
RR1 VDD VOUT1 VSS ppolyf_u L=60u W=1u
RR2 VDD VOUT2 VSS ppolyf_u L=60u W=1u
RR3 net07 net06 VSS ppolyf_u L=5.085u W=1u
RR4 net09 net06 VSS ppolyf_u L=5.085u W=1u
.ends C17_gf180_sW2_sL1
