.subckt C17_ihp130_sW2_sL1.5 VDD VSS VIN1 VIN2 VOUT1 VOUT2 VB1
XM1 VOUT1 VIN1 net07 VSS sg13_lv_nmos w=8u l=0.39u ng=16 m=1
XM2 VOUT2 VIN2 net09 VSS sg13_lv_nmos w=8u l=0.39u ng=16 m=1
XM3 net06 VB1 VSS VSS sg13_lv_nmos w=8u l=0.39u ng=16 m=1
XRR1 VDD VOUT1 rppd w=1u l=58.055u m=1
XRR2 VDD VOUT2 rppd w=1u l=58.055u m=1
XRR3 net07 net06 rppd w=1u l=3.6u m=1
XRR4 net09 net06 rppd w=1u l=3.6u m=1
.ends C17_ihp130_sW2_sL1.5
