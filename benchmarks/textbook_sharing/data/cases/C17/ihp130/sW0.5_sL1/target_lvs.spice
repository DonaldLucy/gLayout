.subckt C17_ihp130_sW0.5_sL1 VDD VSS VIN1 VIN2 VOUT1 VOUT2 VB1
XM1_f0 VOUT1 VIN1 net07 VSS sg13_lv_nmos w=0.5u l=0.26u
XM1_f1 VOUT1 VIN1 net07 VSS sg13_lv_nmos w=0.5u l=0.26u
XM1_f2 VOUT1 VIN1 net07 VSS sg13_lv_nmos w=0.5u l=0.26u
XM1_f3 VOUT1 VIN1 net07 VSS sg13_lv_nmos w=0.5u l=0.26u
XM2_f0 VOUT2 VIN2 net09 VSS sg13_lv_nmos w=0.5u l=0.26u
XM2_f1 VOUT2 VIN2 net09 VSS sg13_lv_nmos w=0.5u l=0.26u
XM2_f2 VOUT2 VIN2 net09 VSS sg13_lv_nmos w=0.5u l=0.26u
XM2_f3 VOUT2 VIN2 net09 VSS sg13_lv_nmos w=0.5u l=0.26u
XM3_f0 net06 VB1 VSS VSS sg13_lv_nmos w=0.5u l=0.26u
XM3_f1 net06 VB1 VSS VSS sg13_lv_nmos w=0.5u l=0.26u
XM3_f2 net06 VB1 VSS VSS sg13_lv_nmos w=0.5u l=0.26u
XM3_f3 net06 VB1 VSS VSS sg13_lv_nmos w=0.5u l=0.26u
XRR1 VDD VOUT1 rppd w=1u l=58.055u m=1
XRR2 VDD VOUT2 rppd w=1u l=58.055u m=1
XRR3 net07 net06 rppd w=1u l=3.6u m=1
XRR4 net09 net06 rppd w=1u l=3.6u m=1
.ends C17_ihp130_sW0.5_sL1
