.subckt C17_sky130_sW1_sL1 VDD VSS VIN1 VIN2 VOUT1 VOUT2 VB1
XM1_f0 VOUT1 VIN1 net07 VSS sky130_fd_pr__nfet_01v8 w=0.5 l=0.3
XM1_f1 VOUT1 VIN1 net07 VSS sky130_fd_pr__nfet_01v8 w=0.5 l=0.3
XM1_f2 VOUT1 VIN1 net07 VSS sky130_fd_pr__nfet_01v8 w=0.5 l=0.3
XM1_f3 VOUT1 VIN1 net07 VSS sky130_fd_pr__nfet_01v8 w=0.5 l=0.3
XM1_f4 VOUT1 VIN1 net07 VSS sky130_fd_pr__nfet_01v8 w=0.5 l=0.3
XM1_f5 VOUT1 VIN1 net07 VSS sky130_fd_pr__nfet_01v8 w=0.5 l=0.3
XM1_f6 VOUT1 VIN1 net07 VSS sky130_fd_pr__nfet_01v8 w=0.5 l=0.3
XM1_f7 VOUT1 VIN1 net07 VSS sky130_fd_pr__nfet_01v8 w=0.5 l=0.3
XM2_f0 VOUT2 VIN2 net09 VSS sky130_fd_pr__nfet_01v8 w=0.5 l=0.3
XM2_f1 VOUT2 VIN2 net09 VSS sky130_fd_pr__nfet_01v8 w=0.5 l=0.3
XM2_f2 VOUT2 VIN2 net09 VSS sky130_fd_pr__nfet_01v8 w=0.5 l=0.3
XM2_f3 VOUT2 VIN2 net09 VSS sky130_fd_pr__nfet_01v8 w=0.5 l=0.3
XM2_f4 VOUT2 VIN2 net09 VSS sky130_fd_pr__nfet_01v8 w=0.5 l=0.3
XM2_f5 VOUT2 VIN2 net09 VSS sky130_fd_pr__nfet_01v8 w=0.5 l=0.3
XM2_f6 VOUT2 VIN2 net09 VSS sky130_fd_pr__nfet_01v8 w=0.5 l=0.3
XM2_f7 VOUT2 VIN2 net09 VSS sky130_fd_pr__nfet_01v8 w=0.5 l=0.3
XM3_f0 net06 VB1 VSS VSS sky130_fd_pr__nfet_01v8 w=0.5 l=0.3
XM3_f1 net06 VB1 VSS VSS sky130_fd_pr__nfet_01v8 w=0.5 l=0.3
XM3_f2 net06 VB1 VSS VSS sky130_fd_pr__nfet_01v8 w=0.5 l=0.3
XM3_f3 net06 VB1 VSS VSS sky130_fd_pr__nfet_01v8 w=0.5 l=0.3
XM3_f4 net06 VB1 VSS VSS sky130_fd_pr__nfet_01v8 w=0.5 l=0.3
XM3_f5 net06 VB1 VSS VSS sky130_fd_pr__nfet_01v8 w=0.5 l=0.3
XM3_f6 net06 VB1 VSS VSS sky130_fd_pr__nfet_01v8 w=0.5 l=0.3
XM3_f7 net06 VB1 VSS VSS sky130_fd_pr__nfet_01v8 w=0.5 l=0.3
XRR1 VDD VOUT1 VSS sky130_fd_pr__res_high_po_0p35 l=17.55 mult=1
XRR2 VDD VOUT2 VSS sky130_fd_pr__res_high_po_0p35 l=17.55 mult=1
XRR3 net07 net06 VSS sky130_fd_pr__res_high_po_0p35 l=1.25 mult=1
XRR4 net09 net06 VSS sky130_fd_pr__res_high_po_0p35 l=1.25 mult=1
.ends C17_sky130_sW1_sL1
