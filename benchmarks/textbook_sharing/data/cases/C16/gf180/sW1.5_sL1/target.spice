.subckt C16_gf180_sW1.5_sL1 VDD VSS VIN1 VIN2 VOUT1 VOUT2 IB1
MM1 VOUT1 VIN1 IB1 VSS nfet_03v3 w=6u l=0.56u nf=12 m=1
MM2 VOUT2 VIN2 IB1 VSS nfet_03v3 w=6u l=0.56u nf=12 m=1
XRR1 VDD VOUT1 VSS ppolyf_u r_width=1u r_length=60u
XRR2 VDD VOUT2 VSS ppolyf_u r_width=1u r_length=60u
.ends C16_gf180_sW1.5_sL1
