.subckt C16_gf180_sW0.5_sL2 VDD VSS VIN1 VIN2 VOUT1 VOUT2 IB1
MM1_f0 VOUT1 VIN1 IB1 VSS nfet_03v3 w=0.5u l=1.12u
MM1_f1 VOUT1 VIN1 IB1 VSS nfet_03v3 w=0.5u l=1.12u
MM1_f2 VOUT1 VIN1 IB1 VSS nfet_03v3 w=0.5u l=1.12u
MM1_f3 VOUT1 VIN1 IB1 VSS nfet_03v3 w=0.5u l=1.12u
MM2_f0 VOUT2 VIN2 IB1 VSS nfet_03v3 w=0.5u l=1.12u
MM2_f1 VOUT2 VIN2 IB1 VSS nfet_03v3 w=0.5u l=1.12u
MM2_f2 VOUT2 VIN2 IB1 VSS nfet_03v3 w=0.5u l=1.12u
MM2_f3 VOUT2 VIN2 IB1 VSS nfet_03v3 w=0.5u l=1.12u
RR1 VDD VOUT1 VSS ppolyf_u L=60u W=1u
RR2 VDD VOUT2 VSS ppolyf_u L=60u W=1u
.ends C16_gf180_sW0.5_sL2
