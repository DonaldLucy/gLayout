.subckt C16_ihp130_sW2_sL2 VDD VSS VIN1 VIN2 VOUT1 VOUT2 IB1
XM1_f0 VOUT1 VIN1 IB1 VSS sg13_lv_nmos w=0.5u l=0.52u
XM1_f1 VOUT1 VIN1 IB1 VSS sg13_lv_nmos w=0.5u l=0.52u
XM1_f2 VOUT1 VIN1 IB1 VSS sg13_lv_nmos w=0.5u l=0.52u
XM1_f3 VOUT1 VIN1 IB1 VSS sg13_lv_nmos w=0.5u l=0.52u
XM1_f4 VOUT1 VIN1 IB1 VSS sg13_lv_nmos w=0.5u l=0.52u
XM1_f5 VOUT1 VIN1 IB1 VSS sg13_lv_nmos w=0.5u l=0.52u
XM1_f6 VOUT1 VIN1 IB1 VSS sg13_lv_nmos w=0.5u l=0.52u
XM1_f7 VOUT1 VIN1 IB1 VSS sg13_lv_nmos w=0.5u l=0.52u
XM1_f8 VOUT1 VIN1 IB1 VSS sg13_lv_nmos w=0.5u l=0.52u
XM1_f9 VOUT1 VIN1 IB1 VSS sg13_lv_nmos w=0.5u l=0.52u
XM1_f10 VOUT1 VIN1 IB1 VSS sg13_lv_nmos w=0.5u l=0.52u
XM1_f11 VOUT1 VIN1 IB1 VSS sg13_lv_nmos w=0.5u l=0.52u
XM1_f12 VOUT1 VIN1 IB1 VSS sg13_lv_nmos w=0.5u l=0.52u
XM1_f13 VOUT1 VIN1 IB1 VSS sg13_lv_nmos w=0.5u l=0.52u
XM1_f14 VOUT1 VIN1 IB1 VSS sg13_lv_nmos w=0.5u l=0.52u
XM1_f15 VOUT1 VIN1 IB1 VSS sg13_lv_nmos w=0.5u l=0.52u
XM2_f0 VOUT2 VIN2 IB1 VSS sg13_lv_nmos w=0.5u l=0.52u
XM2_f1 VOUT2 VIN2 IB1 VSS sg13_lv_nmos w=0.5u l=0.52u
XM2_f2 VOUT2 VIN2 IB1 VSS sg13_lv_nmos w=0.5u l=0.52u
XM2_f3 VOUT2 VIN2 IB1 VSS sg13_lv_nmos w=0.5u l=0.52u
XM2_f4 VOUT2 VIN2 IB1 VSS sg13_lv_nmos w=0.5u l=0.52u
XM2_f5 VOUT2 VIN2 IB1 VSS sg13_lv_nmos w=0.5u l=0.52u
XM2_f6 VOUT2 VIN2 IB1 VSS sg13_lv_nmos w=0.5u l=0.52u
XM2_f7 VOUT2 VIN2 IB1 VSS sg13_lv_nmos w=0.5u l=0.52u
XM2_f8 VOUT2 VIN2 IB1 VSS sg13_lv_nmos w=0.5u l=0.52u
XM2_f9 VOUT2 VIN2 IB1 VSS sg13_lv_nmos w=0.5u l=0.52u
XM2_f10 VOUT2 VIN2 IB1 VSS sg13_lv_nmos w=0.5u l=0.52u
XM2_f11 VOUT2 VIN2 IB1 VSS sg13_lv_nmos w=0.5u l=0.52u
XM2_f12 VOUT2 VIN2 IB1 VSS sg13_lv_nmos w=0.5u l=0.52u
XM2_f13 VOUT2 VIN2 IB1 VSS sg13_lv_nmos w=0.5u l=0.52u
XM2_f14 VOUT2 VIN2 IB1 VSS sg13_lv_nmos w=0.5u l=0.52u
XM2_f15 VOUT2 VIN2 IB1 VSS sg13_lv_nmos w=0.5u l=0.52u
XRR1 VDD VOUT1 rppd w=1u l=46.385u m=1
XRR2 VDD VOUT2 rppd w=1u l=46.385u m=1
.ends C16_ihp130_sW2_sL2
