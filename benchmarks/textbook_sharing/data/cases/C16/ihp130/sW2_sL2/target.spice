.subckt C16_ihp130_sW2_sL2 VDD VSS VIN1 VIN2 VOUT1 VOUT2 IB1
XM1 VOUT1 VIN1 IB1 VSS sg13_lv_nmos w=8u l=0.52u ng=16 m=1
XM2 VOUT2 VIN2 IB1 VSS sg13_lv_nmos w=8u l=0.52u ng=16 m=1
XRR1 VDD VOUT1 rppd w=1u l=46.385u m=1
XRR2 VDD VOUT2 rppd w=1u l=46.385u m=1
.ends C16_ihp130_sW2_sL2
