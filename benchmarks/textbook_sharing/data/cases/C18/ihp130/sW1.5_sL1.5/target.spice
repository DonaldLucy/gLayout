.subckt C18_ihp130_sW1.5_sL1.5 VDD VSS VIN1 VOUT1 VB1
XM1 net13 VIN1 VSS VSS sg13_lv_nmos w=3u l=0.39u ng=6 m=1
XM2 net9 VB1 VDD VDD sg13_lv_pmos w=6u l=0.39u ng=12 m=1
XM3 net9 net9 net22 VSS sg13_lv_nmos w=12u l=0.39u ng=24 m=1
XM4 net13 net13 net22 VDD sg13_lv_pmos w=24u l=0.39u ng=48 m=1
XM5 VDD net9 VOUT1 VSS sg13_lv_nmos w=24u l=0.39u ng=48 m=1
XM6 VSS net13 VOUT1 VDD sg13_lv_pmos w=48u l=0.39u ng=96 m=1
.ends C18_ihp130_sW1.5_sL1.5
