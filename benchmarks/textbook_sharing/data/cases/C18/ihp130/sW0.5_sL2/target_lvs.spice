.subckt C18_ihp130_sW0.5_sL2 VDD VSS VIN1 VOUT1 VB1
XM1_f0 net13 VIN1 VSS VSS sg13_lv_nmos w=0.5u l=0.52u
XM1_f1 net13 VIN1 VSS VSS sg13_lv_nmos w=0.5u l=0.52u
XM2_f0 net9 VB1 VDD VDD sg13_lv_pmos w=0.5u l=0.52u
XM2_f1 net9 VB1 VDD VDD sg13_lv_pmos w=0.5u l=0.52u
XM2_f2 net9 VB1 VDD VDD sg13_lv_pmos w=0.5u l=0.52u
XM2_f3 net9 VB1 VDD VDD sg13_lv_pmos w=0.5u l=0.52u
XM3_f0 net9 net9 net22 VSS sg13_lv_nmos w=0.5u l=0.52u
XM3_f1 net9 net9 net22 VSS sg13_lv_nmos w=0.5u l=0.52u
XM3_f2 net9 net9 net22 VSS sg13_lv_nmos w=0.5u l=0.52u
XM3_f3 net9 net9 net22 VSS sg13_lv_nmos w=0.5u l=0.52u
XM3_f4 net9 net9 net22 VSS sg13_lv_nmos w=0.5u l=0.52u
XM3_f5 net9 net9 net22 VSS sg13_lv_nmos w=0.5u l=0.52u
XM3_f6 net9 net9 net22 VSS sg13_lv_nmos w=0.5u l=0.52u
XM3_f7 net9 net9 net22 VSS sg13_lv_nmos w=0.5u l=0.52u
XM4_f0 net13 net13 net22 VDD sg13_lv_pmos w=0.5u l=0.52u
XM4_f1 net13 net13 net22 VDD sg13_lv_pmos w=0.5u l=0.52u
XM4_f2 net13 net13 net22 VDD sg13_lv_pmos w=0.5u l=0.52u
XM4_f3 net13 net13 net22 VDD sg13_lv_pmos w=0.5u l=0.52u
XM4_f4 net13 net13 net22 VDD sg13_lv_pmos w=0.5u l=0.52u
XM4_f5 net13 net13 net22 VDD sg13_lv_pmos w=0.5u l=0.52u
XM4_f6 net13 net13 net22 VDD sg13_lv_pmos w=0.5u l=0.52u
XM4_f7 net13 net13 net22 VDD sg13_lv_pmos w=0.5u l=0.52u
XM4_f8 net13 net13 net22 VDD sg13_lv_pmos w=0.5u l=0.52u
XM4_f9 net13 net13 net22 VDD sg13_lv_pmos w=0.5u l=0.52u
XM4_f10 net13 net13 net22 VDD sg13_lv_pmos w=0.5u l=0.52u
XM4_f11 net13 net13 net22 VDD sg13_lv_pmos w=0.5u l=0.52u
XM4_f12 net13 net13 net22 VDD sg13_lv_pmos w=0.5u l=0.52u
XM4_f13 net13 net13 net22 VDD sg13_lv_pmos w=0.5u l=0.52u
XM4_f14 net13 net13 net22 VDD sg13_lv_pmos w=0.5u l=0.52u
XM4_f15 net13 net13 net22 VDD sg13_lv_pmos w=0.5u l=0.52u
XM5_f0 VDD net9 VOUT1 VSS sg13_lv_nmos w=0.5u l=0.52u
XM5_f1 VDD net9 VOUT1 VSS sg13_lv_nmos w=0.5u l=0.52u
XM5_f2 VDD net9 VOUT1 VSS sg13_lv_nmos w=0.5u l=0.52u
XM5_f3 VDD net9 VOUT1 VSS sg13_lv_nmos w=0.5u l=0.52u
XM5_f4 VDD net9 VOUT1 VSS sg13_lv_nmos w=0.5u l=0.52u
XM5_f5 VDD net9 VOUT1 VSS sg13_lv_nmos w=0.5u l=0.52u
XM5_f6 VDD net9 VOUT1 VSS sg13_lv_nmos w=0.5u l=0.52u
XM5_f7 VDD net9 VOUT1 VSS sg13_lv_nmos w=0.5u l=0.52u
XM5_f8 VDD net9 VOUT1 VSS sg13_lv_nmos w=0.5u l=0.52u
XM5_f9 VDD net9 VOUT1 VSS sg13_lv_nmos w=0.5u l=0.52u
XM5_f10 VDD net9 VOUT1 VSS sg13_lv_nmos w=0.5u l=0.52u
XM5_f11 VDD net9 VOUT1 VSS sg13_lv_nmos w=0.5u l=0.52u
XM5_f12 VDD net9 VOUT1 VSS sg13_lv_nmos w=0.5u l=0.52u
XM5_f13 VDD net9 VOUT1 VSS sg13_lv_nmos w=0.5u l=0.52u
XM5_f14 VDD net9 VOUT1 VSS sg13_lv_nmos w=0.5u l=0.52u
XM5_f15 VDD net9 VOUT1 VSS sg13_lv_nmos w=0.5u l=0.52u
XM6_f0 VSS net13 VOUT1 VDD sg13_lv_pmos w=0.5u l=0.52u
XM6_f1 VSS net13 VOUT1 VDD sg13_lv_pmos w=0.5u l=0.52u
XM6_f2 VSS net13 VOUT1 VDD sg13_lv_pmos w=0.5u l=0.52u
XM6_f3 VSS net13 VOUT1 VDD sg13_lv_pmos w=0.5u l=0.52u
XM6_f4 VSS net13 VOUT1 VDD sg13_lv_pmos w=0.5u l=0.52u
XM6_f5 VSS net13 VOUT1 VDD sg13_lv_pmos w=0.5u l=0.52u
XM6_f6 VSS net13 VOUT1 VDD sg13_lv_pmos w=0.5u l=0.52u
XM6_f7 VSS net13 VOUT1 VDD sg13_lv_pmos w=0.5u l=0.52u
XM6_f8 VSS net13 VOUT1 VDD sg13_lv_pmos w=0.5u l=0.52u
XM6_f9 VSS net13 VOUT1 VDD sg13_lv_pmos w=0.5u l=0.52u
XM6_f10 VSS net13 VOUT1 VDD sg13_lv_pmos w=0.5u l=0.52u
XM6_f11 VSS net13 VOUT1 VDD sg13_lv_pmos w=0.5u l=0.52u
XM6_f12 VSS net13 VOUT1 VDD sg13_lv_pmos w=0.5u l=0.52u
XM6_f13 VSS net13 VOUT1 VDD sg13_lv_pmos w=0.5u l=0.52u
XM6_f14 VSS net13 VOUT1 VDD sg13_lv_pmos w=0.5u l=0.52u
XM6_f15 VSS net13 VOUT1 VDD sg13_lv_pmos w=0.5u l=0.52u
XM6_f16 VSS net13 VOUT1 VDD sg13_lv_pmos w=0.5u l=0.52u
XM6_f17 VSS net13 VOUT1 VDD sg13_lv_pmos w=0.5u l=0.52u
XM6_f18 VSS net13 VOUT1 VDD sg13_lv_pmos w=0.5u l=0.52u
XM6_f19 VSS net13 VOUT1 VDD sg13_lv_pmos w=0.5u l=0.52u
XM6_f20 VSS net13 VOUT1 VDD sg13_lv_pmos w=0.5u l=0.52u
XM6_f21 VSS net13 VOUT1 VDD sg13_lv_pmos w=0.5u l=0.52u
XM6_f22 VSS net13 VOUT1 VDD sg13_lv_pmos w=0.5u l=0.52u
XM6_f23 VSS net13 VOUT1 VDD sg13_lv_pmos w=0.5u l=0.52u
XM6_f24 VSS net13 VOUT1 VDD sg13_lv_pmos w=0.5u l=0.52u
XM6_f25 VSS net13 VOUT1 VDD sg13_lv_pmos w=0.5u l=0.52u
XM6_f26 VSS net13 VOUT1 VDD sg13_lv_pmos w=0.5u l=0.52u
XM6_f27 VSS net13 VOUT1 VDD sg13_lv_pmos w=0.5u l=0.52u
XM6_f28 VSS net13 VOUT1 VDD sg13_lv_pmos w=0.5u l=0.52u
XM6_f29 VSS net13 VOUT1 VDD sg13_lv_pmos w=0.5u l=0.52u
XM6_f30 VSS net13 VOUT1 VDD sg13_lv_pmos w=0.5u l=0.52u
XM6_f31 VSS net13 VOUT1 VDD sg13_lv_pmos w=0.5u l=0.52u
.ends C18_ihp130_sW0.5_sL2
