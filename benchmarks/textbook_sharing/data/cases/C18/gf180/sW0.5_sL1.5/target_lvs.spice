.subckt C18_gf180_sW0.5_sL1.5 VDD VSS VIN1 VOUT1 VB1
MM1_f0 net13 VIN1 VSS VSS nfet_03v3 w=0.5u l=0.84u
MM1_f1 net13 VIN1 VSS VSS nfet_03v3 w=0.5u l=0.84u
MM2_f0 net9 VB1 VDD VDD pfet_03v3 w=0.5u l=0.84u
MM2_f1 net9 VB1 VDD VDD pfet_03v3 w=0.5u l=0.84u
MM2_f2 net9 VB1 VDD VDD pfet_03v3 w=0.5u l=0.84u
MM2_f3 net9 VB1 VDD VDD pfet_03v3 w=0.5u l=0.84u
MM3_f0 net9 net9 net22 VSS nfet_03v3 w=0.5u l=0.84u
MM3_f1 net9 net9 net22 VSS nfet_03v3 w=0.5u l=0.84u
MM3_f2 net9 net9 net22 VSS nfet_03v3 w=0.5u l=0.84u
MM3_f3 net9 net9 net22 VSS nfet_03v3 w=0.5u l=0.84u
MM3_f4 net9 net9 net22 VSS nfet_03v3 w=0.5u l=0.84u
MM3_f5 net9 net9 net22 VSS nfet_03v3 w=0.5u l=0.84u
MM3_f6 net9 net9 net22 VSS nfet_03v3 w=0.5u l=0.84u
MM3_f7 net9 net9 net22 VSS nfet_03v3 w=0.5u l=0.84u
MM4_f0 net13 net13 net22 VDD pfet_03v3 w=0.5u l=0.84u
MM4_f1 net13 net13 net22 VDD pfet_03v3 w=0.5u l=0.84u
MM4_f2 net13 net13 net22 VDD pfet_03v3 w=0.5u l=0.84u
MM4_f3 net13 net13 net22 VDD pfet_03v3 w=0.5u l=0.84u
MM4_f4 net13 net13 net22 VDD pfet_03v3 w=0.5u l=0.84u
MM4_f5 net13 net13 net22 VDD pfet_03v3 w=0.5u l=0.84u
MM4_f6 net13 net13 net22 VDD pfet_03v3 w=0.5u l=0.84u
MM4_f7 net13 net13 net22 VDD pfet_03v3 w=0.5u l=0.84u
MM4_f8 net13 net13 net22 VDD pfet_03v3 w=0.5u l=0.84u
MM4_f9 net13 net13 net22 VDD pfet_03v3 w=0.5u l=0.84u
MM4_f10 net13 net13 net22 VDD pfet_03v3 w=0.5u l=0.84u
MM4_f11 net13 net13 net22 VDD pfet_03v3 w=0.5u l=0.84u
MM4_f12 net13 net13 net22 VDD pfet_03v3 w=0.5u l=0.84u
MM4_f13 net13 net13 net22 VDD pfet_03v3 w=0.5u l=0.84u
MM4_f14 net13 net13 net22 VDD pfet_03v3 w=0.5u l=0.84u
MM4_f15 net13 net13 net22 VDD pfet_03v3 w=0.5u l=0.84u
MM5_f0 VDD net9 VOUT1 VSS nfet_03v3 w=0.5u l=0.84u
MM5_f1 VDD net9 VOUT1 VSS nfet_03v3 w=0.5u l=0.84u
MM5_f2 VDD net9 VOUT1 VSS nfet_03v3 w=0.5u l=0.84u
MM5_f3 VDD net9 VOUT1 VSS nfet_03v3 w=0.5u l=0.84u
MM5_f4 VDD net9 VOUT1 VSS nfet_03v3 w=0.5u l=0.84u
MM5_f5 VDD net9 VOUT1 VSS nfet_03v3 w=0.5u l=0.84u
MM5_f6 VDD net9 VOUT1 VSS nfet_03v3 w=0.5u l=0.84u
MM5_f7 VDD net9 VOUT1 VSS nfet_03v3 w=0.5u l=0.84u
MM5_f8 VDD net9 VOUT1 VSS nfet_03v3 w=0.5u l=0.84u
MM5_f9 VDD net9 VOUT1 VSS nfet_03v3 w=0.5u l=0.84u
MM5_f10 VDD net9 VOUT1 VSS nfet_03v3 w=0.5u l=0.84u
MM5_f11 VDD net9 VOUT1 VSS nfet_03v3 w=0.5u l=0.84u
MM5_f12 VDD net9 VOUT1 VSS nfet_03v3 w=0.5u l=0.84u
MM5_f13 VDD net9 VOUT1 VSS nfet_03v3 w=0.5u l=0.84u
MM5_f14 VDD net9 VOUT1 VSS nfet_03v3 w=0.5u l=0.84u
MM5_f15 VDD net9 VOUT1 VSS nfet_03v3 w=0.5u l=0.84u
MM6_f0 VSS net13 VOUT1 VDD pfet_03v3 w=0.5u l=0.84u
MM6_f1 VSS net13 VOUT1 VDD pfet_03v3 w=0.5u l=0.84u
MM6_f2 VSS net13 VOUT1 VDD pfet_03v3 w=0.5u l=0.84u
MM6_f3 VSS net13 VOUT1 VDD pfet_03v3 w=0.5u l=0.84u
MM6_f4 VSS net13 VOUT1 VDD pfet_03v3 w=0.5u l=0.84u
MM6_f5 VSS net13 VOUT1 VDD pfet_03v3 w=0.5u l=0.84u
MM6_f6 VSS net13 VOUT1 VDD pfet_03v3 w=0.5u l=0.84u
MM6_f7 VSS net13 VOUT1 VDD pfet_03v3 w=0.5u l=0.84u
MM6_f8 VSS net13 VOUT1 VDD pfet_03v3 w=0.5u l=0.84u
MM6_f9 VSS net13 VOUT1 VDD pfet_03v3 w=0.5u l=0.84u
MM6_f10 VSS net13 VOUT1 VDD pfet_03v3 w=0.5u l=0.84u
MM6_f11 VSS net13 VOUT1 VDD pfet_03v3 w=0.5u l=0.84u
MM6_f12 VSS net13 VOUT1 VDD pfet_03v3 w=0.5u l=0.84u
MM6_f13 VSS net13 VOUT1 VDD pfet_03v3 w=0.5u l=0.84u
MM6_f14 VSS net13 VOUT1 VDD pfet_03v3 w=0.5u l=0.84u
MM6_f15 VSS net13 VOUT1 VDD pfet_03v3 w=0.5u l=0.84u
MM6_f16 VSS net13 VOUT1 VDD pfet_03v3 w=0.5u l=0.84u
MM6_f17 VSS net13 VOUT1 VDD pfet_03v3 w=0.5u l=0.84u
MM6_f18 VSS net13 VOUT1 VDD pfet_03v3 w=0.5u l=0.84u
MM6_f19 VSS net13 VOUT1 VDD pfet_03v3 w=0.5u l=0.84u
MM6_f20 VSS net13 VOUT1 VDD pfet_03v3 w=0.5u l=0.84u
MM6_f21 VSS net13 VOUT1 VDD pfet_03v3 w=0.5u l=0.84u
MM6_f22 VSS net13 VOUT1 VDD pfet_03v3 w=0.5u l=0.84u
MM6_f23 VSS net13 VOUT1 VDD pfet_03v3 w=0.5u l=0.84u
MM6_f24 VSS net13 VOUT1 VDD pfet_03v3 w=0.5u l=0.84u
MM6_f25 VSS net13 VOUT1 VDD pfet_03v3 w=0.5u l=0.84u
MM6_f26 VSS net13 VOUT1 VDD pfet_03v3 w=0.5u l=0.84u
MM6_f27 VSS net13 VOUT1 VDD pfet_03v3 w=0.5u l=0.84u
MM6_f28 VSS net13 VOUT1 VDD pfet_03v3 w=0.5u l=0.84u
MM6_f29 VSS net13 VOUT1 VDD pfet_03v3 w=0.5u l=0.84u
MM6_f30 VSS net13 VOUT1 VDD pfet_03v3 w=0.5u l=0.84u
MM6_f31 VSS net13 VOUT1 VDD pfet_03v3 w=0.5u l=0.84u
.ends C18_gf180_sW0.5_sL1.5
