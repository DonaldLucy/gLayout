.subckt C18_gf180_sW1.5_sL2 VDD VSS VIN1 VOUT1 VB1
MM1 net13 VIN1 VSS VSS nfet_03v3 w=3u l=1.12u nf=6 m=1
MM2 net9 VB1 VDD VDD pfet_03v3 w=6u l=1.12u nf=12 m=1
MM3 net9 net9 net22 VSS nfet_03v3 w=12u l=1.12u nf=24 m=1
MM4 net13 net13 net22 VDD pfet_03v3 w=24u l=1.12u nf=48 m=1
MM5 VDD net9 VOUT1 VSS nfet_03v3 w=24u l=1.12u nf=48 m=1
MM6 VSS net13 VOUT1 VDD pfet_03v3 w=48u l=1.12u nf=96 m=1
.ends C18_gf180_sW1.5_sL2
