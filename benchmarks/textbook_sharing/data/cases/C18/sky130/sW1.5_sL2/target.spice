.subckt C18_sky130_sW1.5_sL2 VDD VSS VIN1 VOUT1 VB1
XM1 net13 VIN1 VSS VSS sky130_fd_pr__nfet_01v8 w=3 l=0.6 nf=6
XM2 net9 VB1 VDD VDD sky130_fd_pr__pfet_01v8 w=6 l=0.6 nf=12
XM3 net9 net9 net22 VSS sky130_fd_pr__nfet_01v8 w=12 l=0.6 nf=24
XM4 net13 net13 net22 VDD sky130_fd_pr__pfet_01v8 w=24 l=0.6 nf=48
XM5 VDD net9 VOUT1 VSS sky130_fd_pr__nfet_01v8 w=24 l=0.6 nf=48
XM6 VSS net13 VOUT1 VDD sky130_fd_pr__pfet_01v8 w=48 l=0.6 nf=96
.ends C18_sky130_sW1.5_sL2
