.subckt C18_sky130_sW2_sL1.5 VDD VSS VIN1 VOUT1 VB1
XM1_f0 net13 VIN1 VSS VSS sky130_fd_pr__nfet_01v8 w=0.5 l=0.45
XM1_f1 net13 VIN1 VSS VSS sky130_fd_pr__nfet_01v8 w=0.5 l=0.45
XM1_f2 net13 VIN1 VSS VSS sky130_fd_pr__nfet_01v8 w=0.5 l=0.45
XM1_f3 net13 VIN1 VSS VSS sky130_fd_pr__nfet_01v8 w=0.5 l=0.45
XM1_f4 net13 VIN1 VSS VSS sky130_fd_pr__nfet_01v8 w=0.5 l=0.45
XM1_f5 net13 VIN1 VSS VSS sky130_fd_pr__nfet_01v8 w=0.5 l=0.45
XM1_f6 net13 VIN1 VSS VSS sky130_fd_pr__nfet_01v8 w=0.5 l=0.45
XM1_f7 net13 VIN1 VSS VSS sky130_fd_pr__nfet_01v8 w=0.5 l=0.45
XM2_f0 net9 VB1 VDD VDD sky130_fd_pr__pfet_01v8 w=0.5 l=0.45
XM2_f1 net9 VB1 VDD VDD sky130_fd_pr__pfet_01v8 w=0.5 l=0.45
XM2_f2 net9 VB1 VDD VDD sky130_fd_pr__pfet_01v8 w=0.5 l=0.45
XM2_f3 net9 VB1 VDD VDD sky130_fd_pr__pfet_01v8 w=0.5 l=0.45
XM2_f4 net9 VB1 VDD VDD sky130_fd_pr__pfet_01v8 w=0.5 l=0.45
XM2_f5 net9 VB1 VDD VDD sky130_fd_pr__pfet_01v8 w=0.5 l=0.45
XM2_f6 net9 VB1 VDD VDD sky130_fd_pr__pfet_01v8 w=0.5 l=0.45
XM2_f7 net9 VB1 VDD VDD sky130_fd_pr__pfet_01v8 w=0.5 l=0.45
XM2_f8 net9 VB1 VDD VDD sky130_fd_pr__pfet_01v8 w=0.5 l=0.45
XM2_f9 net9 VB1 VDD VDD sky130_fd_pr__pfet_01v8 w=0.5 l=0.45
XM2_f10 net9 VB1 VDD VDD sky130_fd_pr__pfet_01v8 w=0.5 l=0.45
XM2_f11 net9 VB1 VDD VDD sky130_fd_pr__pfet_01v8 w=0.5 l=0.45
XM2_f12 net9 VB1 VDD VDD sky130_fd_pr__pfet_01v8 w=0.5 l=0.45
XM2_f13 net9 VB1 VDD VDD sky130_fd_pr__pfet_01v8 w=0.5 l=0.45
XM2_f14 net9 VB1 VDD VDD sky130_fd_pr__pfet_01v8 w=0.5 l=0.45
XM2_f15 net9 VB1 VDD VDD sky130_fd_pr__pfet_01v8 w=0.5 l=0.45
XM3_f0 net9 net9 net22 VSS sky130_fd_pr__nfet_01v8 w=0.5 l=0.45
XM3_f1 net9 net9 net22 VSS sky130_fd_pr__nfet_01v8 w=0.5 l=0.45
XM3_f2 net9 net9 net22 VSS sky130_fd_pr__nfet_01v8 w=0.5 l=0.45
XM3_f3 net9 net9 net22 VSS sky130_fd_pr__nfet_01v8 w=0.5 l=0.45
XM3_f4 net9 net9 net22 VSS sky130_fd_pr__nfet_01v8 w=0.5 l=0.45
XM3_f5 net9 net9 net22 VSS sky130_fd_pr__nfet_01v8 w=0.5 l=0.45
XM3_f6 net9 net9 net22 VSS sky130_fd_pr__nfet_01v8 w=0.5 l=0.45
XM3_f7 net9 net9 net22 VSS sky130_fd_pr__nfet_01v8 w=0.5 l=0.45
XM3_f8 net9 net9 net22 VSS sky130_fd_pr__nfet_01v8 w=0.5 l=0.45
XM3_f9 net9 net9 net22 VSS sky130_fd_pr__nfet_01v8 w=0.5 l=0.45
XM3_f10 net9 net9 net22 VSS sky130_fd_pr__nfet_01v8 w=0.5 l=0.45
XM3_f11 net9 net9 net22 VSS sky130_fd_pr__nfet_01v8 w=0.5 l=0.45
XM3_f12 net9 net9 net22 VSS sky130_fd_pr__nfet_01v8 w=0.5 l=0.45
XM3_f13 net9 net9 net22 VSS sky130_fd_pr__nfet_01v8 w=0.5 l=0.45
XM3_f14 net9 net9 net22 VSS sky130_fd_pr__nfet_01v8 w=0.5 l=0.45
XM3_f15 net9 net9 net22 VSS sky130_fd_pr__nfet_01v8 w=0.5 l=0.45
XM3_f16 net9 net9 net22 VSS sky130_fd_pr__nfet_01v8 w=0.5 l=0.45
XM3_f17 net9 net9 net22 VSS sky130_fd_pr__nfet_01v8 w=0.5 l=0.45
XM3_f18 net9 net9 net22 VSS sky130_fd_pr__nfet_01v8 w=0.5 l=0.45
XM3_f19 net9 net9 net22 VSS sky130_fd_pr__nfet_01v8 w=0.5 l=0.45
XM3_f20 net9 net9 net22 VSS sky130_fd_pr__nfet_01v8 w=0.5 l=0.45
XM3_f21 net9 net9 net22 VSS sky130_fd_pr__nfet_01v8 w=0.5 l=0.45
XM3_f22 net9 net9 net22 VSS sky130_fd_pr__nfet_01v8 w=0.5 l=0.45
XM3_f23 net9 net9 net22 VSS sky130_fd_pr__nfet_01v8 w=0.5 l=0.45
XM3_f24 net9 net9 net22 VSS sky130_fd_pr__nfet_01v8 w=0.5 l=0.45
XM3_f25 net9 net9 net22 VSS sky130_fd_pr__nfet_01v8 w=0.5 l=0.45
XM3_f26 net9 net9 net22 VSS sky130_fd_pr__nfet_01v8 w=0.5 l=0.45
XM3_f27 net9 net9 net22 VSS sky130_fd_pr__nfet_01v8 w=0.5 l=0.45
XM3_f28 net9 net9 net22 VSS sky130_fd_pr__nfet_01v8 w=0.5 l=0.45
XM3_f29 net9 net9 net22 VSS sky130_fd_pr__nfet_01v8 w=0.5 l=0.45
XM3_f30 net9 net9 net22 VSS sky130_fd_pr__nfet_01v8 w=0.5 l=0.45
XM3_f31 net9 net9 net22 VSS sky130_fd_pr__nfet_01v8 w=0.5 l=0.45
XM4_f0 net13 net13 net22 VDD sky130_fd_pr__pfet_01v8 w=0.5 l=0.45
XM4_f1 net13 net13 net22 VDD sky130_fd_pr__pfet_01v8 w=0.5 l=0.45
XM4_f2 net13 net13 net22 VDD sky130_fd_pr__pfet_01v8 w=0.5 l=0.45
XM4_f3 net13 net13 net22 VDD sky130_fd_pr__pfet_01v8 w=0.5 l=0.45
XM4_f4 net13 net13 net22 VDD sky130_fd_pr__pfet_01v8 w=0.5 l=0.45
XM4_f5 net13 net13 net22 VDD sky130_fd_pr__pfet_01v8 w=0.5 l=0.45
XM4_f6 net13 net13 net22 VDD sky130_fd_pr__pfet_01v8 w=0.5 l=0.45
XM4_f7 net13 net13 net22 VDD sky130_fd_pr__pfet_01v8 w=0.5 l=0.45
XM4_f8 net13 net13 net22 VDD sky130_fd_pr__pfet_01v8 w=0.5 l=0.45
XM4_f9 net13 net13 net22 VDD sky130_fd_pr__pfet_01v8 w=0.5 l=0.45
XM4_f10 net13 net13 net22 VDD sky130_fd_pr__pfet_01v8 w=0.5 l=0.45
XM4_f11 net13 net13 net22 VDD sky130_fd_pr__pfet_01v8 w=0.5 l=0.45
XM4_f12 net13 net13 net22 VDD sky130_fd_pr__pfet_01v8 w=0.5 l=0.45
XM4_f13 net13 net13 net22 VDD sky130_fd_pr__pfet_01v8 w=0.5 l=0.45
XM4_f14 net13 net13 net22 VDD sky130_fd_pr__pfet_01v8 w=0.5 l=0.45
XM4_f15 net13 net13 net22 VDD sky130_fd_pr__pfet_01v8 w=0.5 l=0.45
XM4_f16 net13 net13 net22 VDD sky130_fd_pr__pfet_01v8 w=0.5 l=0.45
XM4_f17 net13 net13 net22 VDD sky130_fd_pr__pfet_01v8 w=0.5 l=0.45
XM4_f18 net13 net13 net22 VDD sky130_fd_pr__pfet_01v8 w=0.5 l=0.45
XM4_f19 net13 net13 net22 VDD sky130_fd_pr__pfet_01v8 w=0.5 l=0.45
XM4_f20 net13 net13 net22 VDD sky130_fd_pr__pfet_01v8 w=0.5 l=0.45
XM4_f21 net13 net13 net22 VDD sky130_fd_pr__pfet_01v8 w=0.5 l=0.45
XM4_f22 net13 net13 net22 VDD sky130_fd_pr__pfet_01v8 w=0.5 l=0.45
XM4_f23 net13 net13 net22 VDD sky130_fd_pr__pfet_01v8 w=0.5 l=0.45
XM4_f24 net13 net13 net22 VDD sky130_fd_pr__pfet_01v8 w=0.5 l=0.45
XM4_f25 net13 net13 net22 VDD sky130_fd_pr__pfet_01v8 w=0.5 l=0.45
XM4_f26 net13 net13 net22 VDD sky130_fd_pr__pfet_01v8 w=0.5 l=0.45
XM4_f27 net13 net13 net22 VDD sky130_fd_pr__pfet_01v8 w=0.5 l=0.45
XM4_f28 net13 net13 net22 VDD sky130_fd_pr__pfet_01v8 w=0.5 l=0.45
XM4_f29 net13 net13 net22 VDD sky130_fd_pr__pfet_01v8 w=0.5 l=0.45
XM4_f30 net13 net13 net22 VDD sky130_fd_pr__pfet_01v8 w=0.5 l=0.45
XM4_f31 net13 net13 net22 VDD sky130_fd_pr__pfet_01v8 w=0.5 l=0.45
XM4_f32 net13 net13 net22 VDD sky130_fd_pr__pfet_01v8 w=0.5 l=0.45
XM4_f33 net13 net13 net22 VDD sky130_fd_pr__pfet_01v8 w=0.5 l=0.45
XM4_f34 net13 net13 net22 VDD sky130_fd_pr__pfet_01v8 w=0.5 l=0.45
XM4_f35 net13 net13 net22 VDD sky130_fd_pr__pfet_01v8 w=0.5 l=0.45
XM4_f36 net13 net13 net22 VDD sky130_fd_pr__pfet_01v8 w=0.5 l=0.45
XM4_f37 net13 net13 net22 VDD sky130_fd_pr__pfet_01v8 w=0.5 l=0.45
XM4_f38 net13 net13 net22 VDD sky130_fd_pr__pfet_01v8 w=0.5 l=0.45
XM4_f39 net13 net13 net22 VDD sky130_fd_pr__pfet_01v8 w=0.5 l=0.45
XM4_f40 net13 net13 net22 VDD sky130_fd_pr__pfet_01v8 w=0.5 l=0.45
XM4_f41 net13 net13 net22 VDD sky130_fd_pr__pfet_01v8 w=0.5 l=0.45
XM4_f42 net13 net13 net22 VDD sky130_fd_pr__pfet_01v8 w=0.5 l=0.45
XM4_f43 net13 net13 net22 VDD sky130_fd_pr__pfet_01v8 w=0.5 l=0.45
XM4_f44 net13 net13 net22 VDD sky130_fd_pr__pfet_01v8 w=0.5 l=0.45
XM4_f45 net13 net13 net22 VDD sky130_fd_pr__pfet_01v8 w=0.5 l=0.45
XM4_f46 net13 net13 net22 VDD sky130_fd_pr__pfet_01v8 w=0.5 l=0.45
XM4_f47 net13 net13 net22 VDD sky130_fd_pr__pfet_01v8 w=0.5 l=0.45
XM4_f48 net13 net13 net22 VDD sky130_fd_pr__pfet_01v8 w=0.5 l=0.45
XM4_f49 net13 net13 net22 VDD sky130_fd_pr__pfet_01v8 w=0.5 l=0.45
XM4_f50 net13 net13 net22 VDD sky130_fd_pr__pfet_01v8 w=0.5 l=0.45
XM4_f51 net13 net13 net22 VDD sky130_fd_pr__pfet_01v8 w=0.5 l=0.45
XM4_f52 net13 net13 net22 VDD sky130_fd_pr__pfet_01v8 w=0.5 l=0.45
XM4_f53 net13 net13 net22 VDD sky130_fd_pr__pfet_01v8 w=0.5 l=0.45
XM4_f54 net13 net13 net22 VDD sky130_fd_pr__pfet_01v8 w=0.5 l=0.45
XM4_f55 net13 net13 net22 VDD sky130_fd_pr__pfet_01v8 w=0.5 l=0.45
XM4_f56 net13 net13 net22 VDD sky130_fd_pr__pfet_01v8 w=0.5 l=0.45
XM4_f57 net13 net13 net22 VDD sky130_fd_pr__pfet_01v8 w=0.5 l=0.45
XM4_f58 net13 net13 net22 VDD sky130_fd_pr__pfet_01v8 w=0.5 l=0.45
XM4_f59 net13 net13 net22 VDD sky130_fd_pr__pfet_01v8 w=0.5 l=0.45
XM4_f60 net13 net13 net22 VDD sky130_fd_pr__pfet_01v8 w=0.5 l=0.45
XM4_f61 net13 net13 net22 VDD sky130_fd_pr__pfet_01v8 w=0.5 l=0.45
XM4_f62 net13 net13 net22 VDD sky130_fd_pr__pfet_01v8 w=0.5 l=0.45
XM4_f63 net13 net13 net22 VDD sky130_fd_pr__pfet_01v8 w=0.5 l=0.45
XM5_f0 VDD net9 VOUT1 VSS sky130_fd_pr__nfet_01v8 w=0.5 l=0.45
XM5_f1 VDD net9 VOUT1 VSS sky130_fd_pr__nfet_01v8 w=0.5 l=0.45
XM5_f2 VDD net9 VOUT1 VSS sky130_fd_pr__nfet_01v8 w=0.5 l=0.45
XM5_f3 VDD net9 VOUT1 VSS sky130_fd_pr__nfet_01v8 w=0.5 l=0.45
XM5_f4 VDD net9 VOUT1 VSS sky130_fd_pr__nfet_01v8 w=0.5 l=0.45
XM5_f5 VDD net9 VOUT1 VSS sky130_fd_pr__nfet_01v8 w=0.5 l=0.45
XM5_f6 VDD net9 VOUT1 VSS sky130_fd_pr__nfet_01v8 w=0.5 l=0.45
XM5_f7 VDD net9 VOUT1 VSS sky130_fd_pr__nfet_01v8 w=0.5 l=0.45
XM5_f8 VDD net9 VOUT1 VSS sky130_fd_pr__nfet_01v8 w=0.5 l=0.45
XM5_f9 VDD net9 VOUT1 VSS sky130_fd_pr__nfet_01v8 w=0.5 l=0.45
XM5_f10 VDD net9 VOUT1 VSS sky130_fd_pr__nfet_01v8 w=0.5 l=0.45
XM5_f11 VDD net9 VOUT1 VSS sky130_fd_pr__nfet_01v8 w=0.5 l=0.45
XM5_f12 VDD net9 VOUT1 VSS sky130_fd_pr__nfet_01v8 w=0.5 l=0.45
XM5_f13 VDD net9 VOUT1 VSS sky130_fd_pr__nfet_01v8 w=0.5 l=0.45
XM5_f14 VDD net9 VOUT1 VSS sky130_fd_pr__nfet_01v8 w=0.5 l=0.45
XM5_f15 VDD net9 VOUT1 VSS sky130_fd_pr__nfet_01v8 w=0.5 l=0.45
XM5_f16 VDD net9 VOUT1 VSS sky130_fd_pr__nfet_01v8 w=0.5 l=0.45
XM5_f17 VDD net9 VOUT1 VSS sky130_fd_pr__nfet_01v8 w=0.5 l=0.45
XM5_f18 VDD net9 VOUT1 VSS sky130_fd_pr__nfet_01v8 w=0.5 l=0.45
XM5_f19 VDD net9 VOUT1 VSS sky130_fd_pr__nfet_01v8 w=0.5 l=0.45
XM5_f20 VDD net9 VOUT1 VSS sky130_fd_pr__nfet_01v8 w=0.5 l=0.45
XM5_f21 VDD net9 VOUT1 VSS sky130_fd_pr__nfet_01v8 w=0.5 l=0.45
XM5_f22 VDD net9 VOUT1 VSS sky130_fd_pr__nfet_01v8 w=0.5 l=0.45
XM5_f23 VDD net9 VOUT1 VSS sky130_fd_pr__nfet_01v8 w=0.5 l=0.45
XM5_f24 VDD net9 VOUT1 VSS sky130_fd_pr__nfet_01v8 w=0.5 l=0.45
XM5_f25 VDD net9 VOUT1 VSS sky130_fd_pr__nfet_01v8 w=0.5 l=0.45
XM5_f26 VDD net9 VOUT1 VSS sky130_fd_pr__nfet_01v8 w=0.5 l=0.45
XM5_f27 VDD net9 VOUT1 VSS sky130_fd_pr__nfet_01v8 w=0.5 l=0.45
XM5_f28 VDD net9 VOUT1 VSS sky130_fd_pr__nfet_01v8 w=0.5 l=0.45
XM5_f29 VDD net9 VOUT1 VSS sky130_fd_pr__nfet_01v8 w=0.5 l=0.45
XM5_f30 VDD net9 VOUT1 VSS sky130_fd_pr__nfet_01v8 w=0.5 l=0.45
XM5_f31 VDD net9 VOUT1 VSS sky130_fd_pr__nfet_01v8 w=0.5 l=0.45
XM5_f32 VDD net9 VOUT1 VSS sky130_fd_pr__nfet_01v8 w=0.5 l=0.45
XM5_f33 VDD net9 VOUT1 VSS sky130_fd_pr__nfet_01v8 w=0.5 l=0.45
XM5_f34 VDD net9 VOUT1 VSS sky130_fd_pr__nfet_01v8 w=0.5 l=0.45
XM5_f35 VDD net9 VOUT1 VSS sky130_fd_pr__nfet_01v8 w=0.5 l=0.45
XM5_f36 VDD net9 VOUT1 VSS sky130_fd_pr__nfet_01v8 w=0.5 l=0.45
XM5_f37 VDD net9 VOUT1 VSS sky130_fd_pr__nfet_01v8 w=0.5 l=0.45
XM5_f38 VDD net9 VOUT1 VSS sky130_fd_pr__nfet_01v8 w=0.5 l=0.45
XM5_f39 VDD net9 VOUT1 VSS sky130_fd_pr__nfet_01v8 w=0.5 l=0.45
XM5_f40 VDD net9 VOUT1 VSS sky130_fd_pr__nfet_01v8 w=0.5 l=0.45
XM5_f41 VDD net9 VOUT1 VSS sky130_fd_pr__nfet_01v8 w=0.5 l=0.45
XM5_f42 VDD net9 VOUT1 VSS sky130_fd_pr__nfet_01v8 w=0.5 l=0.45
XM5_f43 VDD net9 VOUT1 VSS sky130_fd_pr__nfet_01v8 w=0.5 l=0.45
XM5_f44 VDD net9 VOUT1 VSS sky130_fd_pr__nfet_01v8 w=0.5 l=0.45
XM5_f45 VDD net9 VOUT1 VSS sky130_fd_pr__nfet_01v8 w=0.5 l=0.45
XM5_f46 VDD net9 VOUT1 VSS sky130_fd_pr__nfet_01v8 w=0.5 l=0.45
XM5_f47 VDD net9 VOUT1 VSS sky130_fd_pr__nfet_01v8 w=0.5 l=0.45
XM5_f48 VDD net9 VOUT1 VSS sky130_fd_pr__nfet_01v8 w=0.5 l=0.45
XM5_f49 VDD net9 VOUT1 VSS sky130_fd_pr__nfet_01v8 w=0.5 l=0.45
XM5_f50 VDD net9 VOUT1 VSS sky130_fd_pr__nfet_01v8 w=0.5 l=0.45
XM5_f51 VDD net9 VOUT1 VSS sky130_fd_pr__nfet_01v8 w=0.5 l=0.45
XM5_f52 VDD net9 VOUT1 VSS sky130_fd_pr__nfet_01v8 w=0.5 l=0.45
XM5_f53 VDD net9 VOUT1 VSS sky130_fd_pr__nfet_01v8 w=0.5 l=0.45
XM5_f54 VDD net9 VOUT1 VSS sky130_fd_pr__nfet_01v8 w=0.5 l=0.45
XM5_f55 VDD net9 VOUT1 VSS sky130_fd_pr__nfet_01v8 w=0.5 l=0.45
XM5_f56 VDD net9 VOUT1 VSS sky130_fd_pr__nfet_01v8 w=0.5 l=0.45
XM5_f57 VDD net9 VOUT1 VSS sky130_fd_pr__nfet_01v8 w=0.5 l=0.45
XM5_f58 VDD net9 VOUT1 VSS sky130_fd_pr__nfet_01v8 w=0.5 l=0.45
XM5_f59 VDD net9 VOUT1 VSS sky130_fd_pr__nfet_01v8 w=0.5 l=0.45
XM5_f60 VDD net9 VOUT1 VSS sky130_fd_pr__nfet_01v8 w=0.5 l=0.45
XM5_f61 VDD net9 VOUT1 VSS sky130_fd_pr__nfet_01v8 w=0.5 l=0.45
XM5_f62 VDD net9 VOUT1 VSS sky130_fd_pr__nfet_01v8 w=0.5 l=0.45
XM5_f63 VDD net9 VOUT1 VSS sky130_fd_pr__nfet_01v8 w=0.5 l=0.45
XM6_f0 VSS net13 VOUT1 VDD sky130_fd_pr__pfet_01v8 w=0.5 l=0.45
XM6_f1 VSS net13 VOUT1 VDD sky130_fd_pr__pfet_01v8 w=0.5 l=0.45
XM6_f2 VSS net13 VOUT1 VDD sky130_fd_pr__pfet_01v8 w=0.5 l=0.45
XM6_f3 VSS net13 VOUT1 VDD sky130_fd_pr__pfet_01v8 w=0.5 l=0.45
XM6_f4 VSS net13 VOUT1 VDD sky130_fd_pr__pfet_01v8 w=0.5 l=0.45
XM6_f5 VSS net13 VOUT1 VDD sky130_fd_pr__pfet_01v8 w=0.5 l=0.45
XM6_f6 VSS net13 VOUT1 VDD sky130_fd_pr__pfet_01v8 w=0.5 l=0.45
XM6_f7 VSS net13 VOUT1 VDD sky130_fd_pr__pfet_01v8 w=0.5 l=0.45
XM6_f8 VSS net13 VOUT1 VDD sky130_fd_pr__pfet_01v8 w=0.5 l=0.45
XM6_f9 VSS net13 VOUT1 VDD sky130_fd_pr__pfet_01v8 w=0.5 l=0.45
XM6_f10 VSS net13 VOUT1 VDD sky130_fd_pr__pfet_01v8 w=0.5 l=0.45
XM6_f11 VSS net13 VOUT1 VDD sky130_fd_pr__pfet_01v8 w=0.5 l=0.45
XM6_f12 VSS net13 VOUT1 VDD sky130_fd_pr__pfet_01v8 w=0.5 l=0.45
XM6_f13 VSS net13 VOUT1 VDD sky130_fd_pr__pfet_01v8 w=0.5 l=0.45
XM6_f14 VSS net13 VOUT1 VDD sky130_fd_pr__pfet_01v8 w=0.5 l=0.45
XM6_f15 VSS net13 VOUT1 VDD sky130_fd_pr__pfet_01v8 w=0.5 l=0.45
XM6_f16 VSS net13 VOUT1 VDD sky130_fd_pr__pfet_01v8 w=0.5 l=0.45
XM6_f17 VSS net13 VOUT1 VDD sky130_fd_pr__pfet_01v8 w=0.5 l=0.45
XM6_f18 VSS net13 VOUT1 VDD sky130_fd_pr__pfet_01v8 w=0.5 l=0.45
XM6_f19 VSS net13 VOUT1 VDD sky130_fd_pr__pfet_01v8 w=0.5 l=0.45
XM6_f20 VSS net13 VOUT1 VDD sky130_fd_pr__pfet_01v8 w=0.5 l=0.45
XM6_f21 VSS net13 VOUT1 VDD sky130_fd_pr__pfet_01v8 w=0.5 l=0.45
XM6_f22 VSS net13 VOUT1 VDD sky130_fd_pr__pfet_01v8 w=0.5 l=0.45
XM6_f23 VSS net13 VOUT1 VDD sky130_fd_pr__pfet_01v8 w=0.5 l=0.45
XM6_f24 VSS net13 VOUT1 VDD sky130_fd_pr__pfet_01v8 w=0.5 l=0.45
XM6_f25 VSS net13 VOUT1 VDD sky130_fd_pr__pfet_01v8 w=0.5 l=0.45
XM6_f26 VSS net13 VOUT1 VDD sky130_fd_pr__pfet_01v8 w=0.5 l=0.45
XM6_f27 VSS net13 VOUT1 VDD sky130_fd_pr__pfet_01v8 w=0.5 l=0.45
XM6_f28 VSS net13 VOUT1 VDD sky130_fd_pr__pfet_01v8 w=0.5 l=0.45
XM6_f29 VSS net13 VOUT1 VDD sky130_fd_pr__pfet_01v8 w=0.5 l=0.45
XM6_f30 VSS net13 VOUT1 VDD sky130_fd_pr__pfet_01v8 w=0.5 l=0.45
XM6_f31 VSS net13 VOUT1 VDD sky130_fd_pr__pfet_01v8 w=0.5 l=0.45
XM6_f32 VSS net13 VOUT1 VDD sky130_fd_pr__pfet_01v8 w=0.5 l=0.45
XM6_f33 VSS net13 VOUT1 VDD sky130_fd_pr__pfet_01v8 w=0.5 l=0.45
XM6_f34 VSS net13 VOUT1 VDD sky130_fd_pr__pfet_01v8 w=0.5 l=0.45
XM6_f35 VSS net13 VOUT1 VDD sky130_fd_pr__pfet_01v8 w=0.5 l=0.45
XM6_f36 VSS net13 VOUT1 VDD sky130_fd_pr__pfet_01v8 w=0.5 l=0.45
XM6_f37 VSS net13 VOUT1 VDD sky130_fd_pr__pfet_01v8 w=0.5 l=0.45
XM6_f38 VSS net13 VOUT1 VDD sky130_fd_pr__pfet_01v8 w=0.5 l=0.45
XM6_f39 VSS net13 VOUT1 VDD sky130_fd_pr__pfet_01v8 w=0.5 l=0.45
XM6_f40 VSS net13 VOUT1 VDD sky130_fd_pr__pfet_01v8 w=0.5 l=0.45
XM6_f41 VSS net13 VOUT1 VDD sky130_fd_pr__pfet_01v8 w=0.5 l=0.45
XM6_f42 VSS net13 VOUT1 VDD sky130_fd_pr__pfet_01v8 w=0.5 l=0.45
XM6_f43 VSS net13 VOUT1 VDD sky130_fd_pr__pfet_01v8 w=0.5 l=0.45
XM6_f44 VSS net13 VOUT1 VDD sky130_fd_pr__pfet_01v8 w=0.5 l=0.45
XM6_f45 VSS net13 VOUT1 VDD sky130_fd_pr__pfet_01v8 w=0.5 l=0.45
XM6_f46 VSS net13 VOUT1 VDD sky130_fd_pr__pfet_01v8 w=0.5 l=0.45
XM6_f47 VSS net13 VOUT1 VDD sky130_fd_pr__pfet_01v8 w=0.5 l=0.45
XM6_f48 VSS net13 VOUT1 VDD sky130_fd_pr__pfet_01v8 w=0.5 l=0.45
XM6_f49 VSS net13 VOUT1 VDD sky130_fd_pr__pfet_01v8 w=0.5 l=0.45
XM6_f50 VSS net13 VOUT1 VDD sky130_fd_pr__pfet_01v8 w=0.5 l=0.45
XM6_f51 VSS net13 VOUT1 VDD sky130_fd_pr__pfet_01v8 w=0.5 l=0.45
XM6_f52 VSS net13 VOUT1 VDD sky130_fd_pr__pfet_01v8 w=0.5 l=0.45
XM6_f53 VSS net13 VOUT1 VDD sky130_fd_pr__pfet_01v8 w=0.5 l=0.45
XM6_f54 VSS net13 VOUT1 VDD sky130_fd_pr__pfet_01v8 w=0.5 l=0.45
XM6_f55 VSS net13 VOUT1 VDD sky130_fd_pr__pfet_01v8 w=0.5 l=0.45
XM6_f56 VSS net13 VOUT1 VDD sky130_fd_pr__pfet_01v8 w=0.5 l=0.45
XM6_f57 VSS net13 VOUT1 VDD sky130_fd_pr__pfet_01v8 w=0.5 l=0.45
XM6_f58 VSS net13 VOUT1 VDD sky130_fd_pr__pfet_01v8 w=0.5 l=0.45
XM6_f59 VSS net13 VOUT1 VDD sky130_fd_pr__pfet_01v8 w=0.5 l=0.45
XM6_f60 VSS net13 VOUT1 VDD sky130_fd_pr__pfet_01v8 w=0.5 l=0.45
XM6_f61 VSS net13 VOUT1 VDD sky130_fd_pr__pfet_01v8 w=0.5 l=0.45
XM6_f62 VSS net13 VOUT1 VDD sky130_fd_pr__pfet_01v8 w=0.5 l=0.45
XM6_f63 VSS net13 VOUT1 VDD sky130_fd_pr__pfet_01v8 w=0.5 l=0.45
XM6_f64 VSS net13 VOUT1 VDD sky130_fd_pr__pfet_01v8 w=0.5 l=0.45
XM6_f65 VSS net13 VOUT1 VDD sky130_fd_pr__pfet_01v8 w=0.5 l=0.45
XM6_f66 VSS net13 VOUT1 VDD sky130_fd_pr__pfet_01v8 w=0.5 l=0.45
XM6_f67 VSS net13 VOUT1 VDD sky130_fd_pr__pfet_01v8 w=0.5 l=0.45
XM6_f68 VSS net13 VOUT1 VDD sky130_fd_pr__pfet_01v8 w=0.5 l=0.45
XM6_f69 VSS net13 VOUT1 VDD sky130_fd_pr__pfet_01v8 w=0.5 l=0.45
XM6_f70 VSS net13 VOUT1 VDD sky130_fd_pr__pfet_01v8 w=0.5 l=0.45
XM6_f71 VSS net13 VOUT1 VDD sky130_fd_pr__pfet_01v8 w=0.5 l=0.45
XM6_f72 VSS net13 VOUT1 VDD sky130_fd_pr__pfet_01v8 w=0.5 l=0.45
XM6_f73 VSS net13 VOUT1 VDD sky130_fd_pr__pfet_01v8 w=0.5 l=0.45
XM6_f74 VSS net13 VOUT1 VDD sky130_fd_pr__pfet_01v8 w=0.5 l=0.45
XM6_f75 VSS net13 VOUT1 VDD sky130_fd_pr__pfet_01v8 w=0.5 l=0.45
XM6_f76 VSS net13 VOUT1 VDD sky130_fd_pr__pfet_01v8 w=0.5 l=0.45
XM6_f77 VSS net13 VOUT1 VDD sky130_fd_pr__pfet_01v8 w=0.5 l=0.45
XM6_f78 VSS net13 VOUT1 VDD sky130_fd_pr__pfet_01v8 w=0.5 l=0.45
XM6_f79 VSS net13 VOUT1 VDD sky130_fd_pr__pfet_01v8 w=0.5 l=0.45
XM6_f80 VSS net13 VOUT1 VDD sky130_fd_pr__pfet_01v8 w=0.5 l=0.45
XM6_f81 VSS net13 VOUT1 VDD sky130_fd_pr__pfet_01v8 w=0.5 l=0.45
XM6_f82 VSS net13 VOUT1 VDD sky130_fd_pr__pfet_01v8 w=0.5 l=0.45
XM6_f83 VSS net13 VOUT1 VDD sky130_fd_pr__pfet_01v8 w=0.5 l=0.45
XM6_f84 VSS net13 VOUT1 VDD sky130_fd_pr__pfet_01v8 w=0.5 l=0.45
XM6_f85 VSS net13 VOUT1 VDD sky130_fd_pr__pfet_01v8 w=0.5 l=0.45
XM6_f86 VSS net13 VOUT1 VDD sky130_fd_pr__pfet_01v8 w=0.5 l=0.45
XM6_f87 VSS net13 VOUT1 VDD sky130_fd_pr__pfet_01v8 w=0.5 l=0.45
XM6_f88 VSS net13 VOUT1 VDD sky130_fd_pr__pfet_01v8 w=0.5 l=0.45
XM6_f89 VSS net13 VOUT1 VDD sky130_fd_pr__pfet_01v8 w=0.5 l=0.45
XM6_f90 VSS net13 VOUT1 VDD sky130_fd_pr__pfet_01v8 w=0.5 l=0.45
XM6_f91 VSS net13 VOUT1 VDD sky130_fd_pr__pfet_01v8 w=0.5 l=0.45
XM6_f92 VSS net13 VOUT1 VDD sky130_fd_pr__pfet_01v8 w=0.5 l=0.45
XM6_f93 VSS net13 VOUT1 VDD sky130_fd_pr__pfet_01v8 w=0.5 l=0.45
XM6_f94 VSS net13 VOUT1 VDD sky130_fd_pr__pfet_01v8 w=0.5 l=0.45
XM6_f95 VSS net13 VOUT1 VDD sky130_fd_pr__pfet_01v8 w=0.5 l=0.45
XM6_f96 VSS net13 VOUT1 VDD sky130_fd_pr__pfet_01v8 w=0.5 l=0.45
XM6_f97 VSS net13 VOUT1 VDD sky130_fd_pr__pfet_01v8 w=0.5 l=0.45
XM6_f98 VSS net13 VOUT1 VDD sky130_fd_pr__pfet_01v8 w=0.5 l=0.45
XM6_f99 VSS net13 VOUT1 VDD sky130_fd_pr__pfet_01v8 w=0.5 l=0.45
XM6_f100 VSS net13 VOUT1 VDD sky130_fd_pr__pfet_01v8 w=0.5 l=0.45
XM6_f101 VSS net13 VOUT1 VDD sky130_fd_pr__pfet_01v8 w=0.5 l=0.45
XM6_f102 VSS net13 VOUT1 VDD sky130_fd_pr__pfet_01v8 w=0.5 l=0.45
XM6_f103 VSS net13 VOUT1 VDD sky130_fd_pr__pfet_01v8 w=0.5 l=0.45
XM6_f104 VSS net13 VOUT1 VDD sky130_fd_pr__pfet_01v8 w=0.5 l=0.45
XM6_f105 VSS net13 VOUT1 VDD sky130_fd_pr__pfet_01v8 w=0.5 l=0.45
XM6_f106 VSS net13 VOUT1 VDD sky130_fd_pr__pfet_01v8 w=0.5 l=0.45
XM6_f107 VSS net13 VOUT1 VDD sky130_fd_pr__pfet_01v8 w=0.5 l=0.45
XM6_f108 VSS net13 VOUT1 VDD sky130_fd_pr__pfet_01v8 w=0.5 l=0.45
XM6_f109 VSS net13 VOUT1 VDD sky130_fd_pr__pfet_01v8 w=0.5 l=0.45
XM6_f110 VSS net13 VOUT1 VDD sky130_fd_pr__pfet_01v8 w=0.5 l=0.45
XM6_f111 VSS net13 VOUT1 VDD sky130_fd_pr__pfet_01v8 w=0.5 l=0.45
XM6_f112 VSS net13 VOUT1 VDD sky130_fd_pr__pfet_01v8 w=0.5 l=0.45
XM6_f113 VSS net13 VOUT1 VDD sky130_fd_pr__pfet_01v8 w=0.5 l=0.45
XM6_f114 VSS net13 VOUT1 VDD sky130_fd_pr__pfet_01v8 w=0.5 l=0.45
XM6_f115 VSS net13 VOUT1 VDD sky130_fd_pr__pfet_01v8 w=0.5 l=0.45
XM6_f116 VSS net13 VOUT1 VDD sky130_fd_pr__pfet_01v8 w=0.5 l=0.45
XM6_f117 VSS net13 VOUT1 VDD sky130_fd_pr__pfet_01v8 w=0.5 l=0.45
XM6_f118 VSS net13 VOUT1 VDD sky130_fd_pr__pfet_01v8 w=0.5 l=0.45
XM6_f119 VSS net13 VOUT1 VDD sky130_fd_pr__pfet_01v8 w=0.5 l=0.45
XM6_f120 VSS net13 VOUT1 VDD sky130_fd_pr__pfet_01v8 w=0.5 l=0.45
XM6_f121 VSS net13 VOUT1 VDD sky130_fd_pr__pfet_01v8 w=0.5 l=0.45
XM6_f122 VSS net13 VOUT1 VDD sky130_fd_pr__pfet_01v8 w=0.5 l=0.45
XM6_f123 VSS net13 VOUT1 VDD sky130_fd_pr__pfet_01v8 w=0.5 l=0.45
XM6_f124 VSS net13 VOUT1 VDD sky130_fd_pr__pfet_01v8 w=0.5 l=0.45
XM6_f125 VSS net13 VOUT1 VDD sky130_fd_pr__pfet_01v8 w=0.5 l=0.45
XM6_f126 VSS net13 VOUT1 VDD sky130_fd_pr__pfet_01v8 w=0.5 l=0.45
XM6_f127 VSS net13 VOUT1 VDD sky130_fd_pr__pfet_01v8 w=0.5 l=0.45
.ends C18_sky130_sW2_sL1.5
