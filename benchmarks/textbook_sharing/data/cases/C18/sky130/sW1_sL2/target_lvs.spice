.subckt C18_sky130_sW1_sL2 VDD VSS VIN1 VOUT1 VB1
XM1_f0 net13 VIN1 VSS VSS sky130_fd_pr__nfet_01v8 w=0.5 l=0.6
XM1_f1 net13 VIN1 VSS VSS sky130_fd_pr__nfet_01v8 w=0.5 l=0.6
XM1_f2 net13 VIN1 VSS VSS sky130_fd_pr__nfet_01v8 w=0.5 l=0.6
XM1_f3 net13 VIN1 VSS VSS sky130_fd_pr__nfet_01v8 w=0.5 l=0.6
XM2_f0 net9 VB1 VDD VDD sky130_fd_pr__pfet_01v8 w=0.5 l=0.6
XM2_f1 net9 VB1 VDD VDD sky130_fd_pr__pfet_01v8 w=0.5 l=0.6
XM2_f2 net9 VB1 VDD VDD sky130_fd_pr__pfet_01v8 w=0.5 l=0.6
XM2_f3 net9 VB1 VDD VDD sky130_fd_pr__pfet_01v8 w=0.5 l=0.6
XM2_f4 net9 VB1 VDD VDD sky130_fd_pr__pfet_01v8 w=0.5 l=0.6
XM2_f5 net9 VB1 VDD VDD sky130_fd_pr__pfet_01v8 w=0.5 l=0.6
XM2_f6 net9 VB1 VDD VDD sky130_fd_pr__pfet_01v8 w=0.5 l=0.6
XM2_f7 net9 VB1 VDD VDD sky130_fd_pr__pfet_01v8 w=0.5 l=0.6
XM3_f0 net9 net9 net22 VSS sky130_fd_pr__nfet_01v8 w=0.5 l=0.6
XM3_f1 net9 net9 net22 VSS sky130_fd_pr__nfet_01v8 w=0.5 l=0.6
XM3_f2 net9 net9 net22 VSS sky130_fd_pr__nfet_01v8 w=0.5 l=0.6
XM3_f3 net9 net9 net22 VSS sky130_fd_pr__nfet_01v8 w=0.5 l=0.6
XM3_f4 net9 net9 net22 VSS sky130_fd_pr__nfet_01v8 w=0.5 l=0.6
XM3_f5 net9 net9 net22 VSS sky130_fd_pr__nfet_01v8 w=0.5 l=0.6
XM3_f6 net9 net9 net22 VSS sky130_fd_pr__nfet_01v8 w=0.5 l=0.6
XM3_f7 net9 net9 net22 VSS sky130_fd_pr__nfet_01v8 w=0.5 l=0.6
XM3_f8 net9 net9 net22 VSS sky130_fd_pr__nfet_01v8 w=0.5 l=0.6
XM3_f9 net9 net9 net22 VSS sky130_fd_pr__nfet_01v8 w=0.5 l=0.6
XM3_f10 net9 net9 net22 VSS sky130_fd_pr__nfet_01v8 w=0.5 l=0.6
XM3_f11 net9 net9 net22 VSS sky130_fd_pr__nfet_01v8 w=0.5 l=0.6
XM3_f12 net9 net9 net22 VSS sky130_fd_pr__nfet_01v8 w=0.5 l=0.6
XM3_f13 net9 net9 net22 VSS sky130_fd_pr__nfet_01v8 w=0.5 l=0.6
XM3_f14 net9 net9 net22 VSS sky130_fd_pr__nfet_01v8 w=0.5 l=0.6
XM3_f15 net9 net9 net22 VSS sky130_fd_pr__nfet_01v8 w=0.5 l=0.6
XM4_f0 net13 net13 net22 VDD sky130_fd_pr__pfet_01v8 w=0.5 l=0.6
XM4_f1 net13 net13 net22 VDD sky130_fd_pr__pfet_01v8 w=0.5 l=0.6
XM4_f2 net13 net13 net22 VDD sky130_fd_pr__pfet_01v8 w=0.5 l=0.6
XM4_f3 net13 net13 net22 VDD sky130_fd_pr__pfet_01v8 w=0.5 l=0.6
XM4_f4 net13 net13 net22 VDD sky130_fd_pr__pfet_01v8 w=0.5 l=0.6
XM4_f5 net13 net13 net22 VDD sky130_fd_pr__pfet_01v8 w=0.5 l=0.6
XM4_f6 net13 net13 net22 VDD sky130_fd_pr__pfet_01v8 w=0.5 l=0.6
XM4_f7 net13 net13 net22 VDD sky130_fd_pr__pfet_01v8 w=0.5 l=0.6
XM4_f8 net13 net13 net22 VDD sky130_fd_pr__pfet_01v8 w=0.5 l=0.6
XM4_f9 net13 net13 net22 VDD sky130_fd_pr__pfet_01v8 w=0.5 l=0.6
XM4_f10 net13 net13 net22 VDD sky130_fd_pr__pfet_01v8 w=0.5 l=0.6
XM4_f11 net13 net13 net22 VDD sky130_fd_pr__pfet_01v8 w=0.5 l=0.6
XM4_f12 net13 net13 net22 VDD sky130_fd_pr__pfet_01v8 w=0.5 l=0.6
XM4_f13 net13 net13 net22 VDD sky130_fd_pr__pfet_01v8 w=0.5 l=0.6
XM4_f14 net13 net13 net22 VDD sky130_fd_pr__pfet_01v8 w=0.5 l=0.6
XM4_f15 net13 net13 net22 VDD sky130_fd_pr__pfet_01v8 w=0.5 l=0.6
XM4_f16 net13 net13 net22 VDD sky130_fd_pr__pfet_01v8 w=0.5 l=0.6
XM4_f17 net13 net13 net22 VDD sky130_fd_pr__pfet_01v8 w=0.5 l=0.6
XM4_f18 net13 net13 net22 VDD sky130_fd_pr__pfet_01v8 w=0.5 l=0.6
XM4_f19 net13 net13 net22 VDD sky130_fd_pr__pfet_01v8 w=0.5 l=0.6
XM4_f20 net13 net13 net22 VDD sky130_fd_pr__pfet_01v8 w=0.5 l=0.6
XM4_f21 net13 net13 net22 VDD sky130_fd_pr__pfet_01v8 w=0.5 l=0.6
XM4_f22 net13 net13 net22 VDD sky130_fd_pr__pfet_01v8 w=0.5 l=0.6
XM4_f23 net13 net13 net22 VDD sky130_fd_pr__pfet_01v8 w=0.5 l=0.6
XM4_f24 net13 net13 net22 VDD sky130_fd_pr__pfet_01v8 w=0.5 l=0.6
XM4_f25 net13 net13 net22 VDD sky130_fd_pr__pfet_01v8 w=0.5 l=0.6
XM4_f26 net13 net13 net22 VDD sky130_fd_pr__pfet_01v8 w=0.5 l=0.6
XM4_f27 net13 net13 net22 VDD sky130_fd_pr__pfet_01v8 w=0.5 l=0.6
XM4_f28 net13 net13 net22 VDD sky130_fd_pr__pfet_01v8 w=0.5 l=0.6
XM4_f29 net13 net13 net22 VDD sky130_fd_pr__pfet_01v8 w=0.5 l=0.6
XM4_f30 net13 net13 net22 VDD sky130_fd_pr__pfet_01v8 w=0.5 l=0.6
XM4_f31 net13 net13 net22 VDD sky130_fd_pr__pfet_01v8 w=0.5 l=0.6
XM5_f0 VDD net9 VOUT1 VSS sky130_fd_pr__nfet_01v8 w=0.5 l=0.6
XM5_f1 VDD net9 VOUT1 VSS sky130_fd_pr__nfet_01v8 w=0.5 l=0.6
XM5_f2 VDD net9 VOUT1 VSS sky130_fd_pr__nfet_01v8 w=0.5 l=0.6
XM5_f3 VDD net9 VOUT1 VSS sky130_fd_pr__nfet_01v8 w=0.5 l=0.6
XM5_f4 VDD net9 VOUT1 VSS sky130_fd_pr__nfet_01v8 w=0.5 l=0.6
XM5_f5 VDD net9 VOUT1 VSS sky130_fd_pr__nfet_01v8 w=0.5 l=0.6
XM5_f6 VDD net9 VOUT1 VSS sky130_fd_pr__nfet_01v8 w=0.5 l=0.6
XM5_f7 VDD net9 VOUT1 VSS sky130_fd_pr__nfet_01v8 w=0.5 l=0.6
XM5_f8 VDD net9 VOUT1 VSS sky130_fd_pr__nfet_01v8 w=0.5 l=0.6
XM5_f9 VDD net9 VOUT1 VSS sky130_fd_pr__nfet_01v8 w=0.5 l=0.6
XM5_f10 VDD net9 VOUT1 VSS sky130_fd_pr__nfet_01v8 w=0.5 l=0.6
XM5_f11 VDD net9 VOUT1 VSS sky130_fd_pr__nfet_01v8 w=0.5 l=0.6
XM5_f12 VDD net9 VOUT1 VSS sky130_fd_pr__nfet_01v8 w=0.5 l=0.6
XM5_f13 VDD net9 VOUT1 VSS sky130_fd_pr__nfet_01v8 w=0.5 l=0.6
XM5_f14 VDD net9 VOUT1 VSS sky130_fd_pr__nfet_01v8 w=0.5 l=0.6
XM5_f15 VDD net9 VOUT1 VSS sky130_fd_pr__nfet_01v8 w=0.5 l=0.6
XM5_f16 VDD net9 VOUT1 VSS sky130_fd_pr__nfet_01v8 w=0.5 l=0.6
XM5_f17 VDD net9 VOUT1 VSS sky130_fd_pr__nfet_01v8 w=0.5 l=0.6
XM5_f18 VDD net9 VOUT1 VSS sky130_fd_pr__nfet_01v8 w=0.5 l=0.6
XM5_f19 VDD net9 VOUT1 VSS sky130_fd_pr__nfet_01v8 w=0.5 l=0.6
XM5_f20 VDD net9 VOUT1 VSS sky130_fd_pr__nfet_01v8 w=0.5 l=0.6
XM5_f21 VDD net9 VOUT1 VSS sky130_fd_pr__nfet_01v8 w=0.5 l=0.6
XM5_f22 VDD net9 VOUT1 VSS sky130_fd_pr__nfet_01v8 w=0.5 l=0.6
XM5_f23 VDD net9 VOUT1 VSS sky130_fd_pr__nfet_01v8 w=0.5 l=0.6
XM5_f24 VDD net9 VOUT1 VSS sky130_fd_pr__nfet_01v8 w=0.5 l=0.6
XM5_f25 VDD net9 VOUT1 VSS sky130_fd_pr__nfet_01v8 w=0.5 l=0.6
XM5_f26 VDD net9 VOUT1 VSS sky130_fd_pr__nfet_01v8 w=0.5 l=0.6
XM5_f27 VDD net9 VOUT1 VSS sky130_fd_pr__nfet_01v8 w=0.5 l=0.6
XM5_f28 VDD net9 VOUT1 VSS sky130_fd_pr__nfet_01v8 w=0.5 l=0.6
XM5_f29 VDD net9 VOUT1 VSS sky130_fd_pr__nfet_01v8 w=0.5 l=0.6
XM5_f30 VDD net9 VOUT1 VSS sky130_fd_pr__nfet_01v8 w=0.5 l=0.6
XM5_f31 VDD net9 VOUT1 VSS sky130_fd_pr__nfet_01v8 w=0.5 l=0.6
XM6_f0 VSS net13 VOUT1 VDD sky130_fd_pr__pfet_01v8 w=0.5 l=0.6
XM6_f1 VSS net13 VOUT1 VDD sky130_fd_pr__pfet_01v8 w=0.5 l=0.6
XM6_f2 VSS net13 VOUT1 VDD sky130_fd_pr__pfet_01v8 w=0.5 l=0.6
XM6_f3 VSS net13 VOUT1 VDD sky130_fd_pr__pfet_01v8 w=0.5 l=0.6
XM6_f4 VSS net13 VOUT1 VDD sky130_fd_pr__pfet_01v8 w=0.5 l=0.6
XM6_f5 VSS net13 VOUT1 VDD sky130_fd_pr__pfet_01v8 w=0.5 l=0.6
XM6_f6 VSS net13 VOUT1 VDD sky130_fd_pr__pfet_01v8 w=0.5 l=0.6
XM6_f7 VSS net13 VOUT1 VDD sky130_fd_pr__pfet_01v8 w=0.5 l=0.6
XM6_f8 VSS net13 VOUT1 VDD sky130_fd_pr__pfet_01v8 w=0.5 l=0.6
XM6_f9 VSS net13 VOUT1 VDD sky130_fd_pr__pfet_01v8 w=0.5 l=0.6
XM6_f10 VSS net13 VOUT1 VDD sky130_fd_pr__pfet_01v8 w=0.5 l=0.6
XM6_f11 VSS net13 VOUT1 VDD sky130_fd_pr__pfet_01v8 w=0.5 l=0.6
XM6_f12 VSS net13 VOUT1 VDD sky130_fd_pr__pfet_01v8 w=0.5 l=0.6
XM6_f13 VSS net13 VOUT1 VDD sky130_fd_pr__pfet_01v8 w=0.5 l=0.6
XM6_f14 VSS net13 VOUT1 VDD sky130_fd_pr__pfet_01v8 w=0.5 l=0.6
XM6_f15 VSS net13 VOUT1 VDD sky130_fd_pr__pfet_01v8 w=0.5 l=0.6
XM6_f16 VSS net13 VOUT1 VDD sky130_fd_pr__pfet_01v8 w=0.5 l=0.6
XM6_f17 VSS net13 VOUT1 VDD sky130_fd_pr__pfet_01v8 w=0.5 l=0.6
XM6_f18 VSS net13 VOUT1 VDD sky130_fd_pr__pfet_01v8 w=0.5 l=0.6
XM6_f19 VSS net13 VOUT1 VDD sky130_fd_pr__pfet_01v8 w=0.5 l=0.6
XM6_f20 VSS net13 VOUT1 VDD sky130_fd_pr__pfet_01v8 w=0.5 l=0.6
XM6_f21 VSS net13 VOUT1 VDD sky130_fd_pr__pfet_01v8 w=0.5 l=0.6
XM6_f22 VSS net13 VOUT1 VDD sky130_fd_pr__pfet_01v8 w=0.5 l=0.6
XM6_f23 VSS net13 VOUT1 VDD sky130_fd_pr__pfet_01v8 w=0.5 l=0.6
XM6_f24 VSS net13 VOUT1 VDD sky130_fd_pr__pfet_01v8 w=0.5 l=0.6
XM6_f25 VSS net13 VOUT1 VDD sky130_fd_pr__pfet_01v8 w=0.5 l=0.6
XM6_f26 VSS net13 VOUT1 VDD sky130_fd_pr__pfet_01v8 w=0.5 l=0.6
XM6_f27 VSS net13 VOUT1 VDD sky130_fd_pr__pfet_01v8 w=0.5 l=0.6
XM6_f28 VSS net13 VOUT1 VDD sky130_fd_pr__pfet_01v8 w=0.5 l=0.6
XM6_f29 VSS net13 VOUT1 VDD sky130_fd_pr__pfet_01v8 w=0.5 l=0.6
XM6_f30 VSS net13 VOUT1 VDD sky130_fd_pr__pfet_01v8 w=0.5 l=0.6
XM6_f31 VSS net13 VOUT1 VDD sky130_fd_pr__pfet_01v8 w=0.5 l=0.6
XM6_f32 VSS net13 VOUT1 VDD sky130_fd_pr__pfet_01v8 w=0.5 l=0.6
XM6_f33 VSS net13 VOUT1 VDD sky130_fd_pr__pfet_01v8 w=0.5 l=0.6
XM6_f34 VSS net13 VOUT1 VDD sky130_fd_pr__pfet_01v8 w=0.5 l=0.6
XM6_f35 VSS net13 VOUT1 VDD sky130_fd_pr__pfet_01v8 w=0.5 l=0.6
XM6_f36 VSS net13 VOUT1 VDD sky130_fd_pr__pfet_01v8 w=0.5 l=0.6
XM6_f37 VSS net13 VOUT1 VDD sky130_fd_pr__pfet_01v8 w=0.5 l=0.6
XM6_f38 VSS net13 VOUT1 VDD sky130_fd_pr__pfet_01v8 w=0.5 l=0.6
XM6_f39 VSS net13 VOUT1 VDD sky130_fd_pr__pfet_01v8 w=0.5 l=0.6
XM6_f40 VSS net13 VOUT1 VDD sky130_fd_pr__pfet_01v8 w=0.5 l=0.6
XM6_f41 VSS net13 VOUT1 VDD sky130_fd_pr__pfet_01v8 w=0.5 l=0.6
XM6_f42 VSS net13 VOUT1 VDD sky130_fd_pr__pfet_01v8 w=0.5 l=0.6
XM6_f43 VSS net13 VOUT1 VDD sky130_fd_pr__pfet_01v8 w=0.5 l=0.6
XM6_f44 VSS net13 VOUT1 VDD sky130_fd_pr__pfet_01v8 w=0.5 l=0.6
XM6_f45 VSS net13 VOUT1 VDD sky130_fd_pr__pfet_01v8 w=0.5 l=0.6
XM6_f46 VSS net13 VOUT1 VDD sky130_fd_pr__pfet_01v8 w=0.5 l=0.6
XM6_f47 VSS net13 VOUT1 VDD sky130_fd_pr__pfet_01v8 w=0.5 l=0.6
XM6_f48 VSS net13 VOUT1 VDD sky130_fd_pr__pfet_01v8 w=0.5 l=0.6
XM6_f49 VSS net13 VOUT1 VDD sky130_fd_pr__pfet_01v8 w=0.5 l=0.6
XM6_f50 VSS net13 VOUT1 VDD sky130_fd_pr__pfet_01v8 w=0.5 l=0.6
XM6_f51 VSS net13 VOUT1 VDD sky130_fd_pr__pfet_01v8 w=0.5 l=0.6
XM6_f52 VSS net13 VOUT1 VDD sky130_fd_pr__pfet_01v8 w=0.5 l=0.6
XM6_f53 VSS net13 VOUT1 VDD sky130_fd_pr__pfet_01v8 w=0.5 l=0.6
XM6_f54 VSS net13 VOUT1 VDD sky130_fd_pr__pfet_01v8 w=0.5 l=0.6
XM6_f55 VSS net13 VOUT1 VDD sky130_fd_pr__pfet_01v8 w=0.5 l=0.6
XM6_f56 VSS net13 VOUT1 VDD sky130_fd_pr__pfet_01v8 w=0.5 l=0.6
XM6_f57 VSS net13 VOUT1 VDD sky130_fd_pr__pfet_01v8 w=0.5 l=0.6
XM6_f58 VSS net13 VOUT1 VDD sky130_fd_pr__pfet_01v8 w=0.5 l=0.6
XM6_f59 VSS net13 VOUT1 VDD sky130_fd_pr__pfet_01v8 w=0.5 l=0.6
XM6_f60 VSS net13 VOUT1 VDD sky130_fd_pr__pfet_01v8 w=0.5 l=0.6
XM6_f61 VSS net13 VOUT1 VDD sky130_fd_pr__pfet_01v8 w=0.5 l=0.6
XM6_f62 VSS net13 VOUT1 VDD sky130_fd_pr__pfet_01v8 w=0.5 l=0.6
XM6_f63 VSS net13 VOUT1 VDD sky130_fd_pr__pfet_01v8 w=0.5 l=0.6
.ends C18_sky130_sW1_sL2
