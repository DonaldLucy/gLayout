.subckt C12_sky130_sW0.5_sL2 VDD VSS VIN1 VOUT1
XM1_f0 VOUT1 VIN1 VSS VSS sky130_fd_pr__nfet_01v8 w=0.5 l=0.6
XM1_f1 VOUT1 VIN1 VSS VSS sky130_fd_pr__nfet_01v8 w=0.5 l=0.6
XM2_f0 VOUT1 VIN1 VDD VDD sky130_fd_pr__pfet_01v8 w=0.5 l=0.6
XM2_f1 VOUT1 VIN1 VDD VDD sky130_fd_pr__pfet_01v8 w=0.5 l=0.6
XM2_f2 VOUT1 VIN1 VDD VDD sky130_fd_pr__pfet_01v8 w=0.5 l=0.6
XM2_f3 VOUT1 VIN1 VDD VDD sky130_fd_pr__pfet_01v8 w=0.5 l=0.6
.ends C12_sky130_sW0.5_sL2
