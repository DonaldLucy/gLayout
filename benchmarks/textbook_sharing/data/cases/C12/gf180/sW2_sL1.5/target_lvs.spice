.subckt C12_gf180_sW2_sL1.5 VDD VSS VIN1 VOUT1
MM1_f0 VOUT1 VIN1 VSS VSS nfet_03v3 w=0.5u l=0.84u
MM1_f1 VOUT1 VIN1 VSS VSS nfet_03v3 w=0.5u l=0.84u
MM1_f2 VOUT1 VIN1 VSS VSS nfet_03v3 w=0.5u l=0.84u
MM1_f3 VOUT1 VIN1 VSS VSS nfet_03v3 w=0.5u l=0.84u
MM1_f4 VOUT1 VIN1 VSS VSS nfet_03v3 w=0.5u l=0.84u
MM1_f5 VOUT1 VIN1 VSS VSS nfet_03v3 w=0.5u l=0.84u
MM1_f6 VOUT1 VIN1 VSS VSS nfet_03v3 w=0.5u l=0.84u
MM1_f7 VOUT1 VIN1 VSS VSS nfet_03v3 w=0.5u l=0.84u
MM2_f0 VOUT1 VIN1 VDD VDD pfet_03v3 w=0.5u l=0.84u
MM2_f1 VOUT1 VIN1 VDD VDD pfet_03v3 w=0.5u l=0.84u
MM2_f2 VOUT1 VIN1 VDD VDD pfet_03v3 w=0.5u l=0.84u
MM2_f3 VOUT1 VIN1 VDD VDD pfet_03v3 w=0.5u l=0.84u
MM2_f4 VOUT1 VIN1 VDD VDD pfet_03v3 w=0.5u l=0.84u
MM2_f5 VOUT1 VIN1 VDD VDD pfet_03v3 w=0.5u l=0.84u
MM2_f6 VOUT1 VIN1 VDD VDD pfet_03v3 w=0.5u l=0.84u
MM2_f7 VOUT1 VIN1 VDD VDD pfet_03v3 w=0.5u l=0.84u
MM2_f8 VOUT1 VIN1 VDD VDD pfet_03v3 w=0.5u l=0.84u
MM2_f9 VOUT1 VIN1 VDD VDD pfet_03v3 w=0.5u l=0.84u
MM2_f10 VOUT1 VIN1 VDD VDD pfet_03v3 w=0.5u l=0.84u
MM2_f11 VOUT1 VIN1 VDD VDD pfet_03v3 w=0.5u l=0.84u
MM2_f12 VOUT1 VIN1 VDD VDD pfet_03v3 w=0.5u l=0.84u
MM2_f13 VOUT1 VIN1 VDD VDD pfet_03v3 w=0.5u l=0.84u
MM2_f14 VOUT1 VIN1 VDD VDD pfet_03v3 w=0.5u l=0.84u
MM2_f15 VOUT1 VIN1 VDD VDD pfet_03v3 w=0.5u l=0.84u
.ends C12_gf180_sW2_sL1.5
